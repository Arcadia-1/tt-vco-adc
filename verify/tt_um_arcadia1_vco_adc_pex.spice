* NGSPICE file created from tt_um_arcadia1_vco_adc.ext - technology: sky130A

.subckt sky130_fd_pr__res_xhigh_po_0p35_JUTA22 R1_4 R1_3 R1_2 R1_1 R1_0 B R2_5 R2_4
+ R2_3 R2_2 R2_1 R2_0 R1_5
X0 R1_0 R2_0 B.t0 sky130_fd_pr__res_xhigh_po_0p35 l=30
X1 R1_1 R2_1 B.t1 sky130_fd_pr__res_xhigh_po_0p35 l=30
X2 R1_3 R2_3 B.t3 sky130_fd_pr__res_xhigh_po_0p35 l=30
X3 R1_4 R2_4 B.t4 sky130_fd_pr__res_xhigh_po_0p35 l=30
X4 R1_2 R2_2 B.t2 sky130_fd_pr__res_xhigh_po_0p35 l=30
X5 R1_5 R2_5 B.t5 sky130_fd_pr__res_xhigh_po_0p35 l=30
R0 B.n2 B.n1 521.615
R1 B.n1 B.n0 585
R2 B.n18 B.n0 390.378
R3 B.t1 B.n1 35.1069
R4 B.n11 B.t3 30.1797
R5 B.n13 B.t2 11.7026
R6 B.n16 B.t1 6.77542
R7 B.n19 B.n18 538.428
R8 B.n12 B.n3 507.332
R9 B.n14 B.n5 507.332
R10 B.n9 B.n7 438.5
R11 B.n10 B.n8 438.5
R12 B.n12 B.n6 507.332
R13 B.n14 B.n15 52.3208
R14 B.n14 B.n4 742.322
R15 B.n15 B.n4 742.322
R16 B.n17 B.n2 440.317
R17 B.n8 B.n5 1246.43
R18 B.n8 B.n11 1915.88
R19 B.n5 B.n11 835.173
R20 B.n7 B.n6 1246.43
R21 B.n7 B.n11 1915.88
R22 B.n6 B.n11 835.173
R23 B.n6 B.n3 1318.72
R24 B.n6 B.n13 1958
R25 B.n3 B.n13 764.337
R26 B.n12 B.n13 2907.18
R27 B.n5 B.n4 1318.72
R28 B.n5 B.n13 1958
R29 B.n4 B.n13 764.337
R30 B.n14 B.n13 2907.18
R31 B.n18 B.n15 1858.52
R32 B.n19 B.n15 81.3306
R33 B.n19 B.n0 1858.52
R34 B.n15 B.n0 620.966
R35 B.n4 B.n0 1318.72
R36 B.n4 B.n16 764.337
R37 B.n0 B.n16 1958
R38 B.n15 B.n16 2907.18
R39 B.n3 B.n2 1246.43
R40 B.n3 B.n16 757.832
R41 B.n2 B.n16 1915.88
R42 B.n13 B.n16 89.7598
R43 B.n4 B.n3 17512.6
R44 B.n8 B.t3 585.503
R45 B.n8 B.n7 20771.6
R46 B.t3 B.n7 585.503
R47 B.n11 B.t2 76.3821
R48 B.n5 B.t2 1066.9
R49 B.n5 B.n6 20681.1
R50 B.t2 B.n6 1066.9
R51 B.n11 B.n10 6276.49
R52 B.n11 B.n14 6276.49
R53 B.n8 B.n14 1602.64
R54 B.n10 B.n5 1602.64
R55 B.n10 B.n14 112.957
R56 B.n11 B.n12 6276.49
R57 B.n11 B.n9 6276.49
R58 B.n6 B.n9 1602.64
R59 B.n12 B.n7 1602.64
R60 B.n12 B.n9 112.957
R61 B.n16 B.n17 6276.49
R62 B.n16 B.n12 6276.49
R63 B.n2 B.n12 1602.64
R64 B.n17 B.n3 1602.64
R65 B.n17 B.n12 112.957
R66 B.n17 B.n18 25864.8
R67 B.n17 B.n19 3629.14
R68 B.n18 B 5150.73
R69 B.n17 B 402.551
R70 B.n19 B 365.825
R71 B B.t0 138.448
R72 B.n17 B.t0 646.442
R73 B.n19 B.t0 847.721
R74 B.n18 B.t0 625.841
R75 B.t0 B.n2 1828.69
R76 B B.n2 12359.5
R77 B.n19 B.n2 97024.2
R78 B.n18 B.n2 57298.3
R79 B.t5 B.n9 361.307
R80 B.n17 B.n1 5131.08
R81 B.n1 B.n18 1627.81
R82 B.n1 B.t0 70.0975
R83 B.n9 B.n10 2354.86
R84 B.n10 B.t5 361.307
R85 B.n9 B.t4 688.865
R86 B.n10 B.t4 688.865
R87 B.t5 B.t4 103.266
R88 B.t5 B.n8 13044.7
R89 B.n9 B.n8 45746.5
R90 B.t4 B.n8 1468.19
R91 B.n10 B.n7 45746.5
R92 B.t5 B.n7 13044.7
R93 B.t4 B.n7 1468.19
R94 B.t5 B.t3 16118
R95 B.t3 B.t4 112.85
R96 B.t3 B.n10 3624.41
R97 B.t3 B.n9 3624.41
C0 R1_0 R1_1 0.29626f
C1 R2_0 R2_1 0.29626f
C2 R1_1 R1_2 0.29626f
C3 R2_1 R2_2 0.29626f
C4 R1_2 R1_3 0.29626f
C5 R2_2 R2_3 0.29626f
C6 R1_3 R1_4 0.29626f
C7 R2_3 R2_4 0.29626f
C8 R1_4 R1_5 0.29626f
C9 R2_4 R2_5 0.29626f
C10 R2_5 B 0.41339f
C11 R1_5 B 0.41339f
C12 R2_4 B 0.19167f
C13 R1_4 B 0.19167f
C14 R2_3 B 0.19156f
C15 R1_3 B 0.19156f
C16 R2_2 B 0.19156f
C17 R1_2 B 0.19156f
C18 R2_1 B 0.19167f
C19 R1_1 B 0.19167f
C20 R2_0 B 0.41339f
C21 R1_0 B 0.41339f
.ends

.subckt sky130_fd_sc_hd__dfxtp_4 VGND VPWR VNB VPB Q D CLK a_891_413# w_n38_582# a_193_47#
+ a_381_47# a_1062_300# a_475_413# a_634_183# a_27_47#
X0 Q a_1062_300# VPWR VPB.t13 sky130_fd_pr__pfet_01v8_hvt ad=0.135 pd=1.27 as=0.1425 ps=1.285 w=1 l=0.15
X1 a_1020_47# a_27_47.t7 a_891_413# VNB sky130_fd_pr__special_nfet_01v8 ad=0.066 pd=0.745 as=0.0657 ps=0.725 w=0.36 l=0.15
X2 a_572_47# a_193_47# a_475_413# VNB sky130_fd_pr__special_nfet_01v8 ad=0.0687 pd=0.76 as=0.0594 ps=0.69 w=0.36 l=0.15
X3 VPWR a_1062_300# a_975_413# VPB.t9 sky130_fd_pr__pfet_01v8_hvt ad=0.1218 pd=1.42 as=0.09135 ps=0.855 w=0.42 l=0.15
X4 a_634_183# a_475_413# VGND VNB sky130_fd_pr__nfet_01v8 ad=0.0989 pd=0.995 as=0.1493 ps=1.22 w=0.64 l=0.15
X5 VPWR CLK a_27_47.t1 VPB.t0 sky130_fd_pr__pfet_01v8_hvt ad=0.0864 pd=0.91 as=0.1664 ps=1.8 w=0.64 l=0.15
X6 a_381_47# D VPWR VPB.t2 sky130_fd_pr__pfet_01v8_hvt ad=0.0672 pd=0.74 as=0.1092 ps=1.36 w=0.42 l=0.15
X7 a_475_413# a_27_47.t4 a_381_47# VNB sky130_fd_pr__special_nfet_01v8 ad=0.0594 pd=0.69 as=0.066 ps=0.745 w=0.36 l=0.15
X8 VGND a_1062_300# a_1020_47# VNB sky130_fd_pr__nfet_01v8 ad=0.1197 pd=1.41 as=0.066 ps=0.745 w=0.42 l=0.15
X9 VPWR a_634_183# a_568_413# VPB.t5 sky130_fd_pr__pfet_01v8_hvt ad=0.17887 pd=1.26 as=0.0693 ps=0.75 w=0.42 l=0.15
X10 Q a_1062_300# VGND VNB sky130_fd_pr__nfet_01v8 ad=0.08775 pd=0.92 as=0.09262 ps=0.935 w=0.65 l=0.15
X11 a_568_413# a_27_47.t5 a_475_413# VPB.t4 sky130_fd_pr__pfet_01v8_hvt ad=0.0693 pd=0.75 as=0.06615 ps=0.735 w=0.42 l=0.15
X12 a_634_183# a_475_413# VPWR VPB.t6 sky130_fd_pr__pfet_01v8_hvt ad=0.1095 pd=1.075 as=0.17887 ps=1.26 w=0.75 l=0.15
X13 a_975_413# a_193_47# a_891_413# VPB.t8 sky130_fd_pr__pfet_01v8_hvt ad=0.09135 pd=0.855 as=0.0567 ps=0.69 w=0.42 l=0.15
X14 a_193_47# a_27_47.t2 VGND VNB sky130_fd_pr__nfet_01v8 ad=0.1092 pd=1.36 as=0.0567 ps=0.69 w=0.42 l=0.15
X15 a_891_413# a_27_47.t6 a_634_183# VPB.t7 sky130_fd_pr__pfet_01v8_hvt ad=0.0567 pd=0.69 as=0.1095 ps=1.075 w=0.42 l=0.15
X16 Q a_1062_300# VGND VNB sky130_fd_pr__nfet_01v8 ad=0.08775 pd=0.92 as=0.10563 ps=0.975 w=0.65 l=0.15
X17 VGND a_891_413# a_1062_300# VNB sky130_fd_pr__nfet_01v8 ad=0.10563 pd=0.975 as=0.169 ps=1.82 w=0.65 l=0.15
X18 VPWR a_1062_300# Q VPB.t12 sky130_fd_pr__pfet_01v8_hvt ad=0.1425 pd=1.285 as=0.135 ps=1.27 w=1 l=0.15
X19 VGND a_1062_300# Q VNB sky130_fd_pr__nfet_01v8 ad=0.18525 pd=1.87 as=0.08775 ps=0.92 w=0.65 l=0.15
X20 Q a_1062_300# VPWR VPB.t11 sky130_fd_pr__pfet_01v8_hvt ad=0.135 pd=1.27 as=0.1625 ps=1.325 w=1 l=0.15
X21 a_193_47# a_27_47.t3 VPWR VPB.t1 sky130_fd_pr__pfet_01v8_hvt ad=0.1664 pd=1.8 as=0.0864 ps=0.91 w=0.64 l=0.15
X22 VGND a_1062_300# Q VNB sky130_fd_pr__nfet_01v8 ad=0.09262 pd=0.935 as=0.08775 ps=0.92 w=0.65 l=0.15
X23 a_381_47# D VGND VNB sky130_fd_pr__nfet_01v8 ad=0.066 pd=0.745 as=0.1092 ps=1.36 w=0.42 l=0.15
X24 VPWR a_891_413# a_1062_300# VPB.t10 sky130_fd_pr__pfet_01v8_hvt ad=0.1625 pd=1.325 as=0.28 ps=2.56 w=1 l=0.15
X25 a_475_413# a_193_47# a_381_47# VPB.t3 sky130_fd_pr__pfet_01v8_hvt ad=0.06615 pd=0.735 as=0.0672 ps=0.74 w=0.42 l=0.15
X26 a_891_413# a_193_47# a_634_183# VNB sky130_fd_pr__special_nfet_01v8 ad=0.0657 pd=0.725 as=0.0989 ps=0.995 w=0.36 l=0.15
X27 VGND a_634_183# a_572_47# VNB sky130_fd_pr__nfet_01v8 ad=0.1493 pd=1.22 as=0.0687 ps=0.76 w=0.42 l=0.15
X28 VGND CLK a_27_47.t0 VNB sky130_fd_pr__nfet_01v8 ad=0.0567 pd=0.69 as=0.1092 ps=1.36 w=0.42 l=0.15
X29 VPWR a_1062_300# Q VPB.t14 sky130_fd_pr__pfet_01v8_hvt ad=0.28 pd=2.56 as=0.135 ps=1.27 w=1 l=0.15
R0 a_27_47.n0 a_27_47.t0 287.998
R1 a_27_47.t3 a_27_47.t2 885.453
R2 a_27_47.t3 a_27_47.n0 590.755
R3 a_27_47.t2 a_27_47.n0 511.411
R4 a_27_47.t6 a_27_47.t7 1292.21
R5 a_27_47.t6 a_27_47.n1 557.577
R6 a_27_47.t7 a_27_47.n1 982.508
R7 a_27_47.t5 a_27_47.t4 1092.89
R8 a_27_47.t5 a_27_47.n1 366.209
R9 a_27_47.t4 a_27_47.n1 1238.76
R10 a_27_47.t1 a_27_47.n0 1648.52
R11 a_27_47.t1 a_27_47.n1 525.735
R12 a_27_47.n0 a_27_47.n1 47.6308
R13 VPB.t9 VPB.t10 639.253
R14 VPB.t1 VPB.t2 556.386
R15 VPB.t5 VPB.t6 390.654
R16 VPB.t8 VPB.t9 346.262
R17 VPB.t4 VPB.t5 284.113
R18 VPB.t6 VPB.t7 281.154
R19 VPB.t10 VPB.t11 281.154
R20 VPB.t2 VPB.t3 278.193
R21 VPB.t3 VPB.t4 275.235
R22 VPB.t12 VPB.t13 257.478
R23 VPB.t0 VPB.t1 248.599
R24 VPB.t7 VPB.t8 248.599
R25 VPB.t11 VPB.t12 248.599
R26 VPB.t13 VPB.t14 248.599
R27 VPB VPB.t0 192.369
C0 a_27_47.n1 a_193_47# 0.73019f
C1 a_27_47.n1 a_634_183# 0.16874f
C2 a_27_47.n1 a_475_413# 0.17954f
C3 a_27_47.n1 a_1062_300# 0.04869f
C4 a_27_47.n1 a_891_413# 0.0386f
C5 a_27_47.n1 a_381_47# 0.03402f
C6 a_27_47.n1 VPB 0.28264f
C7 a_27_47.n1 CLK 0.21719f
C8 a_27_47.n1 D 0.09699f
C9 a_27_47.n1 VPWR 0.38928f
C10 a_27_47.n1 VGND 0.12672f
C11 a_193_47# a_634_183# 0.13254f
C12 a_193_47# a_475_413# 0.15764f
C13 a_193_47# a_1062_300# 0.03024f
C14 a_193_47# a_891_413# 0.13928f
C15 a_193_47# a_381_47# 0.16362f
C16 a_193_47# VPB 0.14429f
C17 a_193_47# D 0.10461f
C18 a_193_47# VPWR 0.10938f
C19 a_193_47# VGND 0.30758f
C20 a_634_183# a_475_413# 0.24864f
C21 a_634_183# a_891_413# 0.03584f
C22 a_634_183# VPB 0.0766f
C23 a_634_183# VPWR 0.1028f
C24 a_634_183# VGND 0.1258f
C25 a_475_413# a_381_47# 0.03564f
C26 a_475_413# VPB 0.07974f
C27 a_475_413# VPWR 0.17771f
C28 a_475_413# VGND 0.09553f
C29 a_1062_300# a_891_413# 0.28872f
C30 a_1062_300# VPB 0.25625f
C31 a_1062_300# VPWR 0.23812f
C32 a_1062_300# VGND 0.20135f
C33 a_1062_300# Q 0.38792f
C34 a_891_413# VPB 0.07277f
C35 a_891_413# VPWR 0.11789f
C36 a_891_413# VGND 0.11953f
C37 a_381_47# VPB 0.01511f
C38 a_381_47# D 0.07679f
C39 a_381_47# VPWR 0.05399f
C40 a_381_47# VGND 0.04719f
C41 VPB CLK 0.07006f
C42 VPB D 0.09664f
C43 VPB VPWR 0.23797f
C44 VPB VGND 0.01466f
C45 VPB Q 0.0149f
C46 CLK VPWR 0.01941f
C47 CLK VGND 0.01946f
C48 D VPWR 0.02861f
C49 D VGND 0.02781f
C50 VPWR VGND 0.10063f
C51 VPWR Q 0.33902f
C52 VGND Q 0.24277f
C53 Q VNB 0.05925f
C54 VGND VNB 0.98679f
C55 VPWR VNB 0.78052f
C56 D VNB 0.09601f
C57 CLK VNB 0.16282f
C58 VPB VNB 0.09582f
C59 a_381_47# VNB 0.01487f
C60 a_891_413# VNB 0.12371f
C61 a_1062_300# VNB 0.35492f
C62 a_475_413# VNB 0.10023f
C63 a_634_183# VNB 0.11406f
C64 a_193_47# VNB 0.20186f
C65 VPB.t14 VNB 0.17816f
C66 VPB.t13 VNB 0.08234f
C67 VPB.t12 VNB 0.08234f
C68 VPB.t11 VNB 0.08619f
C69 VPB.t10 VNB 0.14975f
C70 VPB.t9 VNB 0.16034f
C71 VPB.t8 VNB 0.09678f
C72 VPB.t7 VNB 0.08619f
C73 VPB.t6 VNB 0.1093f
C74 VPB.t5 VNB 0.10978f
C75 VPB.t4 VNB 0.091f
C76 VPB.t3 VNB 0.09004f
C77 VPB.t2 VNB 0.13578f
C78 VPB.t1 VNB 0.13097f
C79 VPB.t0 VNB 0.07174f
C80 a_27_47.t0 VNB 0.01442f
C81 a_27_47.t3 VNB 0.02033f
C82 a_27_47.t2 VNB 0.01846f
C83 a_27_47.n0 VNB 0.05324f
C84 a_27_47.t6 VNB 0.02259f
C85 a_27_47.t7 VNB 0.02328f
C86 a_27_47.t5 VNB 0.0222f
C87 a_27_47.t4 VNB 0.02292f
C88 a_27_47.n1 VNB 0.14565f
C89 a_27_47.t1 VNB 0.01837f
.ends

.subckt sky130_fd_sc_hd__buf_4 VPWR VGND X A VPB VNB w_n38_582# a_27_47#
X0 VPWR a_27_47# X VPB sky130_fd_pr__pfet_01v8_hvt ad=0.26 pd=2.52 as=0.135 ps=1.27 w=1 l=0.15
X1 X a_27_47# VPWR VPB sky130_fd_pr__pfet_01v8_hvt ad=0.135 pd=1.27 as=0.135 ps=1.27 w=1 l=0.15
X2 VPWR a_27_47# X VPB sky130_fd_pr__pfet_01v8_hvt ad=0.135 pd=1.27 as=0.135 ps=1.27 w=1 l=0.15
X3 X a_27_47# VPWR VPB sky130_fd_pr__pfet_01v8_hvt ad=0.135 pd=1.27 as=0.135 ps=1.27 w=1 l=0.15
X4 X a_27_47# VGND VNB sky130_fd_pr__nfet_01v8 ad=0.08775 pd=0.92 as=0.08775 ps=0.92 w=0.65 l=0.15
X5 X a_27_47# VGND VNB sky130_fd_pr__nfet_01v8 ad=0.08775 pd=0.92 as=0.08775 ps=0.92 w=0.65 l=0.15
X6 VGND a_27_47# X VNB sky130_fd_pr__nfet_01v8 ad=0.08775 pd=0.92 as=0.08775 ps=0.92 w=0.65 l=0.15
X7 VGND a_27_47# X VNB sky130_fd_pr__nfet_01v8 ad=0.169 pd=1.82 as=0.08775 ps=0.92 w=0.65 l=0.15
X8 VPWR A a_27_47# VPB sky130_fd_pr__pfet_01v8_hvt ad=0.135 pd=1.27 as=0.26 ps=2.52 w=1 l=0.15
X9 VGND A a_27_47# VNB sky130_fd_pr__nfet_01v8 ad=0.08775 pd=0.92 as=0.169 ps=1.82 w=0.65 l=0.15
C0 a_27_47# VPB 0.13472f
C1 a_27_47# A 0.17157f
C2 a_27_47# VPWR 0.22227f
C3 a_27_47# X 0.22665f
C4 a_27_47# VGND 0.16941f
C5 VPB A 0.03609f
C6 VPB VPWR 0.08072f
C7 VPB X 0.01753f
C8 A VPWR 0.01843f
C9 A VGND 0.0194f
C10 VPWR X 0.33846f
C11 VPWR VGND 0.07213f
C12 X VGND 0.23387f
C13 VGND VNB 0.37501f
C14 X VNB 0.0305f
C15 VPWR VNB 0.31468f
C16 A VNB 0.10681f
C17 VPB VNB 0.60476f
C18 a_27_47# VNB 0.32625f
.ends

.subckt vco_adc_half mon/A a_520_37976# a_586_37826# w_440_39556# a_586_39570# dff1/Q
+ dff5/Q mon/X dff5/VPB dff0/Q mon/VPB dff6/CLK dff5/D dff2/Q dff3/Q dff4/Q dff4/D
+ dff6/Q mon/VNB
Xdff2 mon/VNB dff5/VPB mon/VNB dff5/VPB dff2/Q dff2/D dff6/CLK dff2/a_891_413# mon/VNB
+ dff2/a_193_47# dff2/a_381_47# dff2/a_1062_300# dff2/a_475_413# dff2/a_634_183# dff2/a_27_47#
+ sky130_fd_sc_hd__dfxtp_4
Xdff3 mon/VNB dff5/VPB mon/VNB dff5/VPB dff3/Q dff3/D dff6/CLK dff3/a_891_413# mon/VNB
+ dff3/a_193_47# dff3/a_381_47# dff3/a_1062_300# dff3/a_475_413# dff3/a_634_183# dff3/a_27_47#
+ sky130_fd_sc_hd__dfxtp_4
Xdff4 mon/VNB dff5/VPB mon/VNB dff5/VPB dff4/Q dff4/D dff6/CLK dff4/a_891_413# mon/VNB
+ dff4/a_193_47# dff4/a_381_47# dff4/a_1062_300# dff4/a_475_413# dff4/a_634_183# dff4/a_27_47#
+ sky130_fd_sc_hd__dfxtp_4
Xdff5 mon/VNB dff5/VPB mon/VNB dff5/VPB dff5/Q dff5/D dff6/CLK dff5/a_891_413# mon/VNB
+ dff5/a_193_47# dff5/a_381_47# dff5/a_1062_300# dff5/a_475_413# dff5/a_634_183# dff5/a_27_47#
+ sky130_fd_sc_hd__dfxtp_4
Xdff6 mon/VNB mon/VPB mon/VNB mon/VPB dff6/Q dff6/D dff6/CLK dff6/a_891_413# mon/VNB
+ dff6/a_193_47# dff6/a_381_47# dff6/a_1062_300# dff6/a_475_413# dff6/a_634_183# dff6/a_27_47#
+ sky130_fd_sc_hd__dfxtp_4
Xmon mon/VPB mon/VNB mon/X mon/A mon/VPB mon/VNB mon/VNB mon/a_27_47# sky130_fd_sc_hd__buf_4
Xdff0 mon/VNB mon/VPB mon/VNB mon/VPB dff0/Q mon/A dff6/CLK dff0/a_891_413# dff0/w_n38_582#
+ dff0/a_193_47# dff0/a_381_47# dff0/a_1062_300# dff0/a_475_413# dff0/a_634_183# dff0/a_27_47#
+ sky130_fd_sc_hd__dfxtp_4
Xdff1 mon/VNB mon/VPB mon/VNB mon/VPB dff1/Q dff1/D dff6/CLK dff1/a_891_413# mon/VNB
+ dff1/a_193_47# dff1/a_381_47# dff1/a_1062_300# dff1/a_475_413# dff1/a_634_183# dff1/a_27_47#
+ sky130_fd_sc_hd__dfxtp_4
X0 a_2154_38124.t1 a_1674_38124.t3 a_2366_39596# w_440_39556.t15 sky130_fd_pr__pfet_01v8 ad=0.33 pd=2.66 as=0.15 ps=1.3 w=1 l=0.15
X1 a_2634_38124.t1 a_2154_38124.t3 a_2846_39596# w_440_39556.t16 sky130_fd_pr__pfet_01v8 ad=0.33 pd=2.66 as=0.15 ps=1.3 w=1 l=0.15
X2 a_1674_38124.t0 a_1882_39434.t2 a_1886_39236# mon/VNB sky130_fd_pr__nfet_01v8 ad=0.165 pd=1.66 as=0.075 ps=0.8 w=0.5 l=0.15
X3 a_1674_38124.t1 a_1882_39434.t2 a_1886_39596# w_440_39556.t14 sky130_fd_pr__pfet_01v8 ad=0.33 pd=2.66 as=0.15 ps=1.3 w=1 l=0.15
X4 mon/VNB a_1882_39434.t3 mon/VNB mon/VNB sky130_fd_pr__nfet_01v8 ad=0.49 pd=3.5 as=7.543 ps=61.37 w=1.4 l=2.86
X5 a_3326_39236# a_1066_39096# mon/VNB mon/VNB sky130_fd_pr__nfet_01v8 ad=0.075 pd=0.8 as=0.165 ps=1.66 w=0.5 l=1
X6 a_3806_39236# a_1066_39096# mon/VNB mon/VNB sky130_fd_pr__nfet_01v8 ad=0.075 pd=0.8 as=0.165 ps=1.66 w=0.5 l=1
X7 a_586_39570.t0 a_586_37826# a_520_37976# mon/VNB sky130_fd_pr__nfet_01v8 ad=1.32 pd=8.66 as=1.32 ps=8.66 w=4 l=1
X8 a_3326_39596# a_586_39570.t7 w_440_39556.t11 w_440_39556.t10 sky130_fd_pr__pfet_01v8 ad=0.15 pd=1.3 as=0.33 ps=2.66 w=1 l=1
X9 a_2366_39236# a_1066_39096# mon/VNB mon/VNB sky130_fd_pr__nfet_01v8 ad=0.075 pd=0.8 as=0.165 ps=1.66 w=0.5 l=1
X10 a_2366_39596# a_586_39570.t5 w_440_39556.t8 w_440_39556.t7 sky130_fd_pr__pfet_01v8 ad=0.15 pd=1.3 as=0.33 ps=2.66 w=1 l=1
X11 a_3806_39596# a_586_39570.t8 w_440_39556.t11 w_440_39556.t12 sky130_fd_pr__pfet_01v8 ad=0.15 pd=1.3 as=0.33 ps=2.66 w=1 l=1
X12 a_2846_39236# a_1066_39096# mon/VNB mon/VNB sky130_fd_pr__nfet_01v8 ad=0.075 pd=0.8 as=0.165 ps=1.66 w=0.5 l=1
X13 a_2846_39596# a_586_39570.t6 w_440_39556.t8 w_440_39556.t9 sky130_fd_pr__pfet_01v8 ad=0.15 pd=1.3 as=0.33 ps=2.66 w=1 l=1
X14 a_1886_39236# a_1066_39096# mon/VNB mon/VNB sky130_fd_pr__nfet_01v8 ad=0.075 pd=0.8 as=0.165 ps=1.66 w=0.5 l=1
X15 a_1886_39596# a_586_39570.t4 w_440_39556.t6 w_440_39556.t5 sky130_fd_pr__pfet_01v8 ad=0.15 pd=1.3 as=0.33 ps=2.66 w=1 l=1
X16 a_1066_39096# a_1066_39096# mon/VNB mon/VNB sky130_fd_pr__nfet_01v8 ad=0.165 pd=1.66 as=0.165 ps=1.66 w=0.5 l=1
X17 a_1066_39096# a_586_39570.t3 w_440_39556.t1 w_440_39556.t4 sky130_fd_pr__pfet_01v8 ad=0.33 pd=2.66 as=0.33 ps=2.66 w=1 l=1
X18 mon/VNB a_4074_38124.t2 mon/VNB mon/VNB sky130_fd_pr__nfet_01v8 ad=0.49 pd=3.5 as=0 ps=0 w=1.4 l=2.86
X19 mon/VNB a_3114_38124.t2 mon/VNB mon/VNB sky130_fd_pr__nfet_01v8 ad=0.49 pd=3.5 as=0 ps=0 w=1.4 l=2.86
X20 a_4074_38124.t0 a_3594_38124.t3 a_4286_39236# mon/VNB sky130_fd_pr__nfet_01v8 ad=0.165 pd=1.66 as=0.075 ps=0.8 w=0.5 l=0.15
X21 mon/VNB a_3594_38124.t2 mon/VNB mon/VNB sky130_fd_pr__nfet_01v8 ad=0.49 pd=3.5 as=0 ps=0 w=1.4 l=2.86
X22 a_1882_39434.t0 a_4074_38124.t3 a_4766_39236# mon/VNB sky130_fd_pr__nfet_01v8 ad=0.165 pd=1.66 as=0.075 ps=0.8 w=0.5 l=0.15
X23 mon/VNB a_2154_38124.t2 mon/VNB mon/VNB sky130_fd_pr__nfet_01v8 ad=0.49 pd=3.5 as=0 ps=0 w=1.4 l=2.86
X24 a_586_39570.t2 a_586_39570.t1 w_440_39556.t1 w_440_39556.t0 sky130_fd_pr__pfet_01v8 ad=0.33 pd=2.66 as=0.33 ps=2.66 w=1 l=1
X25 a_4074_38124.t1 a_3594_38124.t3 a_4286_39596# w_440_39556.t19 sky130_fd_pr__pfet_01v8 ad=0.33 pd=2.66 as=0.15 ps=1.3 w=1 l=0.15
X26 a_3114_38124.t0 a_2634_38124.t3 a_3326_39236# mon/VNB sky130_fd_pr__nfet_01v8 ad=0.165 pd=1.66 as=0.075 ps=0.8 w=0.5 l=0.15
X27 mon/VNB a_2634_38124.t2 mon/VNB mon/VNB sky130_fd_pr__nfet_01v8 ad=0.49 pd=3.5 as=0 ps=0 w=1.4 l=2.86
X28 a_3114_38124.t1 a_2634_38124.t3 a_3326_39596# w_440_39556.t17 sky130_fd_pr__pfet_01v8 ad=0.33 pd=2.66 as=0.15 ps=1.3 w=1 l=0.15
X29 a_1882_39434.t1 a_4074_38124.t3 a_4766_39596# w_440_39556.t20 sky130_fd_pr__pfet_01v8 ad=0.33 pd=2.66 as=0.15 ps=1.3 w=1 l=0.15
X30 a_3594_38124.t0 a_3114_38124.t3 a_3806_39236# mon/VNB sky130_fd_pr__nfet_01v8 ad=0.165 pd=1.66 as=0.075 ps=0.8 w=0.5 l=0.15
X31 a_3594_38124.t1 a_3114_38124.t3 a_3806_39596# w_440_39556.t18 sky130_fd_pr__pfet_01v8 ad=0.33 pd=2.66 as=0.15 ps=1.3 w=1 l=0.15
X32 a_4286_39236# a_1066_39096# mon/VNB mon/VNB sky130_fd_pr__nfet_01v8 ad=0.075 pd=0.8 as=0.165 ps=1.66 w=0.5 l=1
X33 a_4286_39596# a_586_39570.t9 w_440_39556.t3 w_440_39556.t13 sky130_fd_pr__pfet_01v8 ad=0.15 pd=1.3 as=0.33 ps=2.66 w=1 l=1
X34 a_4766_39236# a_1066_39096# mon/VNB mon/VNB sky130_fd_pr__nfet_01v8 ad=0.075 pd=0.8 as=0.165 ps=1.66 w=0.5 l=1
X35 a_4766_39596# a_586_39570.t10 w_440_39556.t3 w_440_39556.t2 sky130_fd_pr__pfet_01v8 ad=0.15 pd=1.3 as=0.33 ps=2.66 w=1 l=1
X36 a_2154_38124.t0 a_1674_38124.t3 a_2366_39236# mon/VNB sky130_fd_pr__nfet_01v8 ad=0.165 pd=1.66 as=0.075 ps=0.8 w=0.5 l=0.15
X37 a_2634_38124.t0 a_2154_38124.t3 a_2846_39236# mon/VNB sky130_fd_pr__nfet_01v8 ad=0.165 pd=1.66 as=0.075 ps=0.8 w=0.5 l=0.15
X38 mon/VNB a_1674_38124.t2 mon/VNB mon/VNB sky130_fd_pr__nfet_01v8 ad=0.49 pd=3.5 as=0 ps=0 w=1.4 l=2.86
R0 w_440_39556.t5 w_440_39556.t4 981.668
R1 w_440_39556.t14 w_440_39556.t7 482.918
R2 w_440_39556.t9 w_440_39556.t15 482.918
R3 w_440_39556.t16 w_440_39556.t10 482.918
R4 w_440_39556.t12 w_440_39556.t17 482.918
R5 w_440_39556.t18 w_440_39556.t13 482.918
R6 w_440_39556.t2 w_440_39556.t19 482.918
R7 w_440_39556.t3 w_440_39556.t20 389.841
R8 w_440_39556.t20 w_440_39556.t2 101.334
R9 w_440_39556# w_440_39556.t3 13.0824
R10 w_440_39556.t6 w_440_39556.t1 1.54998
R11 w_440_39556.t3 w_440_39556.t11 1.2505
R12 w_440_39556.t11 w_440_39556.t8 1.2505
R13 w_440_39556.t8 w_440_39556.t6 1.2505
R14 w_440_39556.t0 w_440_39556.t4 835.909
R15 w_440_39556.t0 w_440_39556.t1 408.753
R16 w_440_39556.t4 w_440_39556.t1 453.336
R17 w_440_39556.t14 w_440_39556.t5 322.767
R18 w_440_39556.t14 w_440_39556.t6 1241.72
R19 w_440_39556.t5 w_440_39556.t6 715.948
R20 w_440_39556.t15 w_440_39556.t7 322.767
R21 w_440_39556.t15 w_440_39556.t8 1241.72
R22 w_440_39556.t7 w_440_39556.t8 715.948
R23 w_440_39556.t16 w_440_39556.t9 322.767
R24 w_440_39556.t16 w_440_39556.t8 1241.72
R25 w_440_39556.t9 w_440_39556.t8 715.948
R26 w_440_39556.t17 w_440_39556.t10 322.767
R27 w_440_39556.t17 w_440_39556.t11 1241.72
R28 w_440_39556.t10 w_440_39556.t11 715.948
R29 w_440_39556.t18 w_440_39556.t12 322.767
R30 w_440_39556.t18 w_440_39556.t11 1241.72
R31 w_440_39556.t12 w_440_39556.t11 715.948
R32 w_440_39556.t19 w_440_39556.t13 322.767
R33 w_440_39556.t19 w_440_39556.t3 1241.72
R34 w_440_39556.t13 w_440_39556.t3 715.948
R35 a_586_39570.n3 a_586_39570.t1 80.3338
R36 a_586_39570.n2 a_586_39570.t4 24.1005
R37 a_586_39570.n1 a_586_39570.t6 24.1005
R38 a_586_39570.n0 a_586_39570.t8 24.1005
R39 a_586_39570.t9 a_586_39570.t10 359.5
R40 a_586_39570.t9 a_586_39570.n0 340.733
R41 a_586_39570.t10 a_586_39570.n0 4382.47
R42 a_586_39570.t7 a_586_39570.n0 341.99
R43 a_586_39570.t7 a_586_39570.n1 341.99
R44 a_586_39570.n0 a_586_39570.n1 4169.03
R45 a_586_39570.t5 a_586_39570.n1 341.99
R46 a_586_39570.t5 a_586_39570.n2 341.99
R47 a_586_39570.n1 a_586_39570.n2 4169.03
R48 a_586_39570.t3 a_586_39570.n2 472.993
R49 a_586_39570.t3 a_586_39570.n3 267.361
R50 a_586_39570.n2 a_586_39570.n3 4506.95
R51 a_586_39570.t0 a_586_39570.t2 1064.31
R52 a_586_39570.t0 a_586_39570.n3 1109.67
R53 a_586_39570.t2 a_586_39570.n3 568.369
R54 a_4074_38124.t0 a_4074_38124.t2 528.236
R55 a_4074_38124.t3 a_4074_38124.t0 61.7417
R56 dff4/D a_4074_38124.t1 34.8114
R57 a_4074_38124.t1 a_4074_38124.t3 33.5064
R58 a_4074_38124.n0 dff4/D 4.25371
R59 dff4/D dff4/D 22.4862
R60 a_4074_38124.n0 dff4/D 22.4862
R61 a_3594_38124.t0 a_3594_38124.t2 528.236
R62 a_3594_38124.t3 a_3594_38124.t0 61.7417
R63 a_3594_38124.t1 a_3594_38124.t3 33.5064
R64 dff3/D a_3594_38124.t1 32.7606
R65 a_3594_38124.n0 dff3/D 1.27132
R66 a_3594_38124.n0 dff3/D 13.8207
R67 dff3/D dff3/D 64.0758
R68 a_3114_38124.t0 a_3114_38124.t2 528.236
R69 a_3114_38124.t3 a_3114_38124.t0 61.7417
R70 a_3114_38124.t1 a_3114_38124.t3 33.5064
R71 dff2/D a_3114_38124.t1 33.3998
R72 a_3114_38124.n0 dff2/D 1.27132
R73 a_3114_38124.n0 dff2/D 13.8207
R74 dff2/D dff2/D 64.0758
R75 a_2634_38124.t0 a_2634_38124.t2 528.236
R76 a_2634_38124.t3 a_2634_38124.t0 61.7417
R77 a_2634_38124.t1 a_2634_38124.t3 33.5064
R78 dff6/D a_2634_38124.t1 31.522
R79 a_2634_38124.n0 dff6/D 4.25371
R80 dff6/D dff6/D 22.4862
R81 a_2634_38124.n0 dff6/D 22.4862
R82 a_2154_38124.t0 a_2154_38124.t2 528.236
R83 a_2154_38124.t3 a_2154_38124.t0 61.7417
R84 a_2154_38124.t1 a_2154_38124.t3 33.5064
R85 dff1/D a_2154_38124.t1 29.9036
R86 a_2154_38124.n0 dff1/D 1.27132
R87 a_2154_38124.n0 dff1/D 13.8207
R88 dff1/D dff1/D 64.0758
R89 a_1882_39434.t0 a_1882_39434.t3 528.236
R90 a_1882_39434.t1 a_1882_39434.t2 68.8946
R91 a_1882_39434.t2 a_1882_39434.t0 39.1534
R92 dff5/D a_1882_39434.t1 34.1722
R93 a_1882_39434.n0 dff5/D 4.25371
R94 dff5/D dff5/D 22.4862
R95 a_1882_39434.n0 dff5/D 22.4862
R96 a_1674_38124.t0 a_1674_38124.t2 528.236
R97 a_1674_38124.t3 a_1674_38124.t0 61.7417
R98 a_1674_38124.t1 a_1674_38124.t3 33.5064
R99 mon/A mon/A 16.2338
R100 a_1674_38124.n0 mon/A 1.27124
R101 a_1674_38124.t1 mon/A 25.3066
R102 a_1674_38124.n0 mon/A 13.8721
R103 mon/A mon/A 64.3143
C0 dff2/a_193_47# dff2/D 0.08326f
C1 dff2/a_193_47# dff4/D 0.0554f
C2 dff2/a_193_47# dff6/CLK 0.08286f
C3 dff2/a_193_47# mon/A 0.01254f
C4 dff2/a_193_47# dff0/Q 0.01285f
C5 dff2/a_634_183# dff4/D 0.02123f
C6 dff2/a_634_183# dff6/CLK 0.01718f
C7 dff2/a_475_413# dff4/D 0.02907f
C8 dff2/a_475_413# mon/a_27_47# 0.01337f
C9 dff2/a_475_413# dff6/CLK 0.02065f
C10 dff2/a_1062_300# dff2/Q 0.03528f
C11 dff2/a_1062_300# dff6/D 0.01399f
C12 dff2/a_1062_300# dff6/CLK 0.06547f
C13 dff2/a_891_413# dff2/Q 0.01092f
C14 dff2/a_891_413# dff6/CLK 0.02741f
C15 dff2/a_381_47# dff2/D 0.01227f
C16 dff2/a_381_47# dff6/CLK 0.01321f
C17 dff2/D dff5/VPB 0.01773f
C18 dff2/D dff3/D 0.91251f
C19 dff2/D dff4/D 0.44039f
C20 dff2/D dff5/D 0.12333f
C21 dff2/D mon/VPB 0.12581f
C22 dff2/D dff6/D 1.10089f
C23 dff2/D mon/X 0.08268f
C24 dff2/D dff0/a_193_47# 0.06079f
C25 dff2/D dff0/a_475_413# 0.02135f
C26 dff2/D dff0/a_381_47# 0.01002f
C27 dff2/D dff6/CLK 0.38003f
C28 dff2/D mon/A 0.94195f
C29 dff2/D dff0/Q 0.02272f
C30 dff2/D dff1/D 0.08243f
C31 dff2/D a_586_39570.t0 0.14513f
C32 dff2/D w_440_39556# 0.37138f
C33 dff2/D a_1066_39096# 0.11088f
C34 dff2/D a_3326_39596# 0.01187f
C35 dff5/VPB dff2/Q 0.21767f
C36 dff5/VPB dff3/D 0.0188f
C37 dff5/VPB dff3/Q 0.17689f
C38 dff5/VPB dff4/a_1062_300# 0.0192f
C39 dff5/VPB dff4/D 0.16326f
C40 dff5/VPB dff4/Q 0.17338f
C41 dff5/VPB dff5/a_1062_300# 0.01664f
C42 dff5/VPB dff5/D 0.17031f
C43 dff5/VPB dff5/Q 0.12965f
C44 dff5/VPB mon/VPB 0.04483f
C45 dff5/VPB dff6/Q 0.05854f
C46 dff5/VPB mon/X 0.03942f
C47 dff5/VPB dff6/CLK 0.50715f
C48 dff5/VPB dff0/Q 0.03496f
C49 dff5/VPB dff1/Q 0.04518f
C50 dff2/Q dff4/a_193_47# 0.01246f
C51 dff2/Q dff4/a_1062_300# 0.01222f
C52 dff2/Q dff4/D 0.02072f
C53 dff2/Q dff4/Q 0.3408f
C54 dff2/Q dff6/Q 0.02772f
C55 dff2/Q dff6/CLK 0.6109f
C56 dff2/Q dff0/Q 0.3551f
C57 dff3/a_193_47# dff3/D 0.08326f
C58 dff3/a_193_47# dff5/D 0.0554f
C59 dff3/a_193_47# dff6/a_1062_300# 0.01098f
C60 dff3/a_193_47# dff6/a_891_413# 0.01276f
C61 dff3/a_193_47# dff6/Q 0.01713f
C62 dff3/a_193_47# dff6/CLK 0.02259f
C63 dff3/a_193_47# dff1/Q 0.01404f
C64 dff3/a_634_183# dff5/D 0.02112f
C65 dff3/a_634_183# dff6/a_1062_300# 0.01389f
C66 dff3/a_475_413# dff5/D 0.02909f
C67 dff3/a_1062_300# dff3/Q 0.03276f
C68 dff3/a_1062_300# dff5/D 0.01128f
C69 dff3/a_1062_300# dff1/Q 0.01786f
C70 dff3/a_891_413# dff1/Q 0.01253f
C71 dff3/a_381_47# dff3/D 0.01227f
C72 dff3/D dff4/D 1.26537f
C73 dff3/D dff5/D 0.34741f
C74 dff3/D dff6/a_193_47# 0.01623f
C75 dff3/D dff6/a_1062_300# 0.03493f
C76 dff3/D dff6/a_891_413# 0.03082f
C77 dff3/D mon/VPB 0.13492f
C78 dff3/D dff6/D 0.04175f
C79 dff3/D dff6/Q 0.09559f
C80 dff3/D dff6/CLK 0.0466f
C81 dff3/D dff1/a_193_47# 0.06104f
C82 dff3/D dff1/a_475_413# 0.02528f
C83 dff3/D dff1/a_381_47# 0.01002f
C84 dff3/D dff1/D 0.24449f
C85 dff3/D a_586_39570.t0 0.14157f
C86 dff3/D w_440_39556# 0.36377f
C87 dff3/D a_1066_39096# 0.11007f
C88 dff3/D a_3806_39596# 0.01177f
C89 dff3/Q dff5/a_1062_300# 0.03096f
C90 dff3/Q dff5/a_891_413# 0.01453f
C91 dff3/Q dff5/D 0.02024f
C92 dff3/Q dff5/Q 0.31939f
C93 dff3/Q dff1/Q 0.36558f
C94 dff4/a_193_47# dff4/D 0.05082f
C95 dff4/a_193_47# dff6/CLK 0.06437f
C96 dff4/a_634_183# dff6/CLK 0.0161f
C97 dff4/a_475_413# dff6/CLK 0.02279f
C98 dff4/a_1062_300# dff4/Q 0.03757f
C99 dff4/a_1062_300# dff6/CLK 0.07403f
C100 dff4/a_891_413# dff4/Q 0.01199f
C101 dff4/a_891_413# dff6/CLK 0.02084f
C102 dff4/a_381_47# dff4/D 0.01244f
C103 dff4/D dff5/D 1.36649f
C104 dff4/D mon/VPB 0.13679f
C105 dff4/D dff6/D 0.15195f
C106 dff4/D dff6/Q 0.02675f
C107 dff4/D mon/a_27_47# 0.0282f
C108 dff4/D mon/X 0.12202f
C109 dff4/D dff0/a_193_47# 0.04895f
C110 dff4/D dff0/a_634_183# 0.01949f
C111 dff4/D dff0/a_1062_300# 0.02264f
C112 dff4/D dff0/a_891_413# 0.02028f
C113 dff4/D dff6/CLK 0.53385f
C114 dff4/D mon/A 0.38739f
C115 dff4/D dff0/Q 0.11268f
C116 dff4/D dff1/D 0.07892f
C117 dff4/D a_586_39570.t0 0.12449f
C118 dff4/D w_440_39556# 0.3691f
C119 dff4/D a_1066_39096# 0.09296f
C120 dff4/D a_4286_39596# 0.01167f
C121 dff4/Q dff5/D 0.01261f
C122 dff4/Q dff6/Q 0.33481f
C123 dff4/Q dff6/CLK 0.44494f
C124 dff5/a_193_47# dff5/D 0.05082f
C125 dff5/a_193_47# dff1/Q 0.0188f
C126 dff5/a_475_413# dff1/Q 0.01075f
C127 dff5/a_1062_300# dff5/Q 0.03708f
C128 dff5/a_381_47# dff5/D 0.01244f
C129 dff5/D dff6/a_1062_300# 0.04083f
C130 dff5/D mon/VPB 0.16586f
C131 dff5/D dff6/D 0.12336f
C132 dff5/D dff6/Q 0.19806f
C133 dff5/D dff6/CLK 0.03585f
C134 dff5/D mon/A 0.19267f
C135 dff5/D dff1/a_193_47# 0.0546f
C136 dff5/D dff1/a_634_183# 0.02349f
C137 dff5/D dff1/a_475_413# 0.01162f
C138 dff5/D dff1/a_1062_300# 0.0353f
C139 dff5/D dff1/a_891_413# 0.02556f
C140 dff5/D dff1/D 0.12315f
C141 dff5/D dff1/Q 0.15723f
C142 dff5/D a_586_39570.t0 0.24106f
C143 dff5/D w_440_39556# 0.60672f
C144 dff5/D a_1066_39096# 0.32727f
C145 dff5/D a_4766_39596# 0.01435f
C146 dff6/a_193_47# dff6/D 0.0509f
C147 dff6/a_193_47# dff6/Q 0.01075f
C148 dff6/a_193_47# dff6/CLK 0.02544f
C149 dff6/a_634_183# dff6/CLK 0.01946f
C150 dff6/a_475_413# dff6/CLK 0.0188f
C151 dff6/a_1062_300# dff6/Q 0.05467f
C152 dff6/a_1062_300# dff1/Q 0.0107f
C153 dff6/a_891_413# dff6/Q 0.01406f
C154 dff6/a_381_47# dff6/D 0.01244f
C155 mon/VPB dff6/D 0.16377f
C156 mon/VPB dff6/Q 0.17354f
C157 mon/VPB mon/a_27_47# 0.08905f
C158 mon/VPB mon/X 0.19289f
C159 mon/VPB dff6/CLK 0.43256f
C160 mon/VPB mon/A 0.14321f
C161 mon/VPB dff0/Q 0.22831f
C162 mon/VPB dff1/D 0.01786f
C163 mon/VPB dff1/Q 0.23034f
C164 dff6/D mon/X 0.0106f
C165 dff6/D dff0/a_1062_300# 0.04092f
C166 dff6/D dff6/CLK 0.14436f
C167 dff6/D mon/A 0.13353f
C168 dff6/D dff0/Q 0.0795f
C169 dff6/D dff1/D 0.63919f
C170 dff6/D a_586_39570.t0 0.14732f
C171 dff6/D w_440_39556# 0.37667f
C172 dff6/D a_1066_39096# 0.11335f
C173 dff6/D a_2846_39596# 0.01201f
C174 dff6/Q dff6/CLK 0.14786f
C175 dff6/Q dff0/Q 0.04899f
C176 dff6/Q dff1/Q 0.60519f
C177 mon/a_27_47# mon/X 0.01946f
C178 mon/a_27_47# dff0/a_1062_300# 0.01029f
C179 mon/a_27_47# dff6/CLK 0.04353f
C180 mon/a_27_47# mon/A 0.0521f
C181 mon/X dff6/CLK 1.05714f
C182 mon/X mon/A 0.06383f
C183 mon/X dff0/Q 0.75636f
C184 dff0/a_193_47# dff6/CLK 0.04812f
C185 dff0/a_193_47# mon/A 0.11839f
C186 dff0/a_634_183# mon/A 0.02046f
C187 dff0/a_475_413# dff6/CLK 0.01181f
C188 dff0/a_475_413# mon/A 0.02815f
C189 dff0/a_1062_300# dff6/CLK 0.06713f
C190 dff0/a_1062_300# dff0/Q 0.03455f
C191 dff0/a_891_413# dff6/CLK 0.01759f
C192 dff0/a_891_413# dff0/Q 0.01466f
C193 dff0/a_381_47# mon/A 0.0127f
C194 dff6/CLK mon/A 0.26033f
C195 dff6/CLK dff0/Q 0.91783f
C196 dff6/CLK dff1/D 0.03781f
C197 mon/A dff0/Q 0.06276f
C198 mon/A dff1/D 0.26649f
C199 mon/A a_586_39570.t0 0.19644f
C200 mon/A w_440_39556# 0.49257f
C201 mon/A a_1066_39096# 0.12936f
C202 mon/A a_1886_39596# 0.01242f
C203 dff1/a_193_47# dff1/D 0.0787f
C204 dff1/a_1062_300# dff1/Q 0.05136f
C205 dff1/a_891_413# dff1/Q 0.0154f
C206 dff1/a_381_47# dff1/D 0.01227f
C207 dff1/D a_586_39570.t0 0.14561f
C208 dff1/D w_440_39556# 0.3655f
C209 dff1/D a_1066_39096# 0.11357f
C210 dff1/D a_2366_39596# 0.01219f
C211 a_586_39570.t0 w_440_39556# 4.27061f
C212 a_586_39570.t0 a_1066_39096# 0.21091f
C213 a_586_39570.t0 a_586_37826# 0.13159f
C214 a_586_39570.t0 a_520_37976# 0.08493f
C215 w_440_39556# a_1066_39096# 0.12812f
C216 a_586_37826# a_520_37976# 0.1605f
C217 a_520_37976# mon/VNB 0.35994f
C218 a_586_37826# mon/VNB 0.38625f
C219 a_1066_39096# mon/VNB 4.18283f
C220 w_440_39556# mon/VNB 0.23323f
C221 a_1674_38124.t2 mon/VNB 0.72489f
C222 a_1674_38124.t0 mon/VNB 0.10977f
C223 a_1674_38124.t3 mon/VNB 0.15171f
C224 a_1674_38124.t1 mon/VNB 0.42826f
C225 a_1882_39434.t3 mon/VNB 0.8086f
C226 a_1882_39434.t0 mon/VNB 0.11833f
C227 a_1882_39434.t2 mon/VNB 0.99596f
C228 a_1882_39434.t1 mon/VNB 0.80425f
C229 a_1882_39434.n0 mon/VNB 0.05768f
C230 a_2154_38124.t2 mon/VNB 0.76411f
C231 a_2154_38124.t0 mon/VNB 0.11571f
C232 a_2154_38124.t3 mon/VNB 0.15992f
C233 a_2154_38124.t1 mon/VNB 0.34237f
C234 a_2634_38124.t2 mon/VNB 0.69114f
C235 a_2634_38124.t0 mon/VNB 0.10466f
C236 a_2634_38124.t3 mon/VNB 0.14465f
C237 a_2634_38124.t1 mon/VNB 0.48092f
C238 a_2634_38124.n0 mon/VNB 0.0493f
C239 a_3114_38124.t2 mon/VNB 0.5531f
C240 a_3114_38124.t0 mon/VNB 0.08376f
C241 a_3114_38124.t3 mon/VNB 0.11576f
C242 a_3114_38124.t1 mon/VNB 0.58938f
C243 a_3594_38124.t2 mon/VNB 0.64959f
C244 a_3594_38124.t0 mon/VNB 0.09837f
C245 a_3594_38124.t3 mon/VNB 0.13595f
C246 a_3594_38124.t1 mon/VNB 0.52342f
C247 a_4074_38124.t2 mon/VNB 0.58833f
C248 a_4074_38124.t0 mon/VNB 0.08909f
C249 a_4074_38124.t3 mon/VNB 0.12313f
C250 a_4074_38124.t1 mon/VNB 0.73621f
C251 a_4074_38124.n0 mon/VNB 0.04197f
C252 a_586_39570.t2 mon/VNB 0.03375f
C253 a_586_39570.t3 mon/VNB 0.12015f
C254 a_586_39570.t4 mon/VNB 0.05091f
C255 a_586_39570.t5 mon/VNB 0.11899f
C256 a_586_39570.t6 mon/VNB 0.05091f
C257 a_586_39570.t7 mon/VNB 0.11899f
C258 a_586_39570.t8 mon/VNB 0.05091f
C259 a_586_39570.t9 mon/VNB 0.12431f
C260 a_586_39570.t10 mon/VNB 0.11783f
C261 a_586_39570.n0 mon/VNB 0.09086f
C262 a_586_39570.n1 mon/VNB 0.09042f
C263 a_586_39570.n2 mon/VNB 0.09502f
C264 a_586_39570.t1 mon/VNB 0.08185f
C265 a_586_39570.n3 mon/VNB 0.06678f
C266 a_586_39570.t0 mon/VNB 0.13956f
C267 w_440_39556.t1 mon/VNB 0.56037f
C268 w_440_39556.t6 mon/VNB 0.27955f
C269 w_440_39556.t8 mon/VNB 0.47894f
C270 w_440_39556.t11 mon/VNB 0.47894f
C271 w_440_39556.t3 mon/VNB 0.71427f
C272 w_440_39556.t13 mon/VNB 0.37718f
C273 w_440_39556.t18 mon/VNB 0.37993f
C274 w_440_39556.t10 mon/VNB 0.37718f
C275 w_440_39556.t16 mon/VNB 0.37993f
C276 w_440_39556.t7 mon/VNB 0.37718f
C277 w_440_39556.t14 mon/VNB 0.37993f
C278 w_440_39556.t0 mon/VNB 0.7501f
C279 w_440_39556.t4 mon/VNB 0.85589f
C280 w_440_39556.t5 mon/VNB 0.62897f
C281 w_440_39556.t15 mon/VNB 0.37993f
C282 w_440_39556.t9 mon/VNB 0.37718f
C283 w_440_39556.t17 mon/VNB 0.37993f
C284 w_440_39556.t12 mon/VNB 0.37718f
C285 w_440_39556.t19 mon/VNB 0.37993f
C286 w_440_39556.t2 mon/VNB 0.29496f
C287 w_440_39556.t20 mon/VNB 0.49712f
C288 dff1/Q mon/VNB 0.55468f
C289 dff1/D mon/VNB 0.56779f
C290 dff1/a_891_413# mon/VNB 0.01402f
C291 dff1/a_1062_300# mon/VNB 0.07759f
C292 dff1/a_193_47# mon/VNB 0.0169f
C293 dff0/Q mon/VNB 0.31011f
C294 mon/A mon/VNB 1.44614f
C295 dff6/CLK mon/VNB 2.22154f
C296 dff0/a_891_413# mon/VNB 0.01561f
C297 dff0/a_1062_300# mon/VNB 0.0555f
C298 dff0/a_475_413# mon/VNB 0.0128f
C299 dff0/a_634_183# mon/VNB 0.01164f
C300 dff0/a_193_47# mon/VNB 0.0242f
C301 mon/X mon/VNB 0.63079f
C302 mon/a_27_47# mon/VNB 0.05623f
C303 dff6/Q mon/VNB 0.36376f
C304 dff6/D mon/VNB 0.64035f
C305 mon/VPB mon/VNB -3.65607f
C306 dff6/a_1062_300# mon/VNB 0.04061f
C307 dff6/a_193_47# mon/VNB 0.01519f
C308 dff5/Q mon/VNB 0.61732f
C309 dff5/D mon/VNB 1.18946f
C310 dff5/a_891_413# mon/VNB 0.01011f
C311 dff5/a_1062_300# mon/VNB 0.07005f
C312 dff5/a_193_47# mon/VNB 0.01912f
C313 dff4/Q mon/VNB 0.22295f
C314 dff4/D mon/VNB 1.03455f
C315 dff4/a_1062_300# mon/VNB 0.04199f
C316 dff4/a_193_47# mon/VNB 0.02021f
C317 dff3/Q mon/VNB 0.35441f
C318 dff3/D mon/VNB 0.81467f
C319 dff3/a_891_413# mon/VNB 0.01216f
C320 dff3/a_1062_300# mon/VNB 0.06289f
C321 dff2/Q mon/VNB 0.22582f
C322 dff5/VPB mon/VNB -4.82399f
C323 dff2/D mon/VNB 0.9632f
C324 dff2/a_1062_300# mon/VNB 0.0341f
C325 dff2/a_193_47# mon/VNB 0.01227f
.ends

.subckt tt_um_arcadia1_vco_adc clk ena rst_n ua[0] ua[1] ua[2] ua[3] ua[4] ua[5] ua[6]
+ ua[7] ui_in[0] ui_in[1] ui_in[2] ui_in[3] ui_in[4] ui_in[5] ui_in[6] ui_in[7] uio_in[0]
+ uio_in[1] uio_in[2] uio_in[3] uio_in[4] uio_in[5] uio_in[6] uio_in[7] uio_out[0]
+ uio_out[1] uio_out[2] uio_out[3] uio_out[4] uio_out[5] uio_out[6] uio_out[7] uo_out[0]
+ uo_out[1] uo_out[2] uo_out[3] uo_out[4] uo_out[5] uo_out[6] uo_out[7] VGND VDPWR
+ VDPWR_uq0 VDPWR_uq1 VGND_uq2 VGND_uq1
XRARR VGND_uq2 RARR/R1_3 VGND_uq2 RARR/R1_1 VGND_uq2 VGND_uq2 VGND_uq2 RARR/R2_4 RARR/R2_3
+ RARR/R2_3 RARR/R2_4 VGND_uq2 VGND_uq2 sky130_fd_pr__res_xhigh_po_0p35_JUTA22
XhalfN halfN/mon/A RARR/R1_1 ua[1] VDPWR halfN/a_586_39570# uio_out[5] uio_out[7]
+ uio_out[0] VDPWR uio_out[1] VDPWR clk halfN/dff5/D uio_out[2] uio_out[6] uio_out[3]
+ halfN/dff4/D uio_out[4] VGND_uq2 vco_adc_half
XhalfP halfP/mon/A RARR/R1_3 ua[0] VDPWR halfP/a_586_39570# uo_out[2] uo_out[0] uo_out[7]
+ VDPWR uo_out[6] VDPWR clk halfP/dff5/D uo_out[5] uo_out[1] uo_out[4] halfP/dff4/D
+ uo_out[3] VGND_uq2 vco_adc_half
R0 VGND_uq2 VGND_uq2 864.947
R1 w_200_0.n156 w_200_0.n7 294.916
R2 w_200_0.n168 w_200_0.n0 1179.3
R3 w_200_0.n169 w_200_0.n0 1179.3
R4 w_200_0.n105 w_200_0.n104 389.438
R5 w_200_0.n161 w_200_0.n160 373.755
R6 w_200_0.n87 w_200_0.n86 384.901
R7 w_200_0.n51 w_200_0.n48 585
R8 w_200_0.n97 w_200_0.n51 546.876
R9 w_200_0.n100 w_200_0.n99 585
R10 w_200_0.n99 w_200_0.n98 585
R11 w_200_0.n50 w_200_0.n1 585
R12 w_200_0.n106 w_200_0.n44 585
R13 w_200_0.n45 w_200_0.n43 585
R14 w_200_0.n112 w_200_0.n111 585
R15 w_200_0.n42 w_200_0.n40 585
R16 w_200_0.n84 w_200_0.n83 585
R17 w_200_0.n81 w_200_0.n72 585
R18 w_200_0.n78 w_200_0.n71 585
R19 w_200_0.n112 w_200_0.n41 585
R20 w_200_0.n108 w_200_0.n46 585
R21 w_200_0.n49 w_200_0.n1 585
R22 w_200_0.n101 w_200_0.n100 585
R23 w_200_0.n102 w_200_0.n101 509.341
R24 w_200_0.n62 w_200_0.n61 333.322
R25 w_200_0.n113 w_200_0.n38 585
R26 w_200_0.n115 w_200_0.n114 430.55
R27 w_200_0.n117 w_200_0.n33 585
R28 w_200_0.n118 w_200_0.n35 585
R29 w_200_0.n116 w_200_0.n36 585
R30 w_200_0.n117 w_200_0.n116 510
R31 w_200_0.n116 w_200_0.n37 480.084
R32 w_200_0.n118 w_200_0.n117 505
R33 w_200_0.n101 w_200_0.n49 394
R34 w_200_0.n99 w_200_0.n51 394
R35 w_200_0.n99 w_200_0.n50 394
R36 w_200_0.n50 w_200_0.n44 390.378
R37 w_200_0.n111 w_200_0.n43 394
R38 w_200_0.n111 w_200_0.n42 391.096
R39 w_200_0.n83 w_200_0.n72 394
R40 w_200_0.n118 w_200_0.n34 315
R41 w_200_0.n114 w_200_0.n38 226.102
R42 w_200_0.n87 w_200_0.n55 223.864
R43 w_200_0.n104 w_200_0.n47 223.864
R44 VGND_uq2 VGND_uq2 36.4394
R45 VGND_uq2 VGND_uq2 0.909331
R46 w_200_0.n150 VGND_uq2 7.05344
R47 VGND_uq2 VGND_uq2 15.7828
R48 VGND_uq2 VGND_uq2 13.6564
R49 VGND_uq2 VGND_uq2 13.6226
R50 VGND_uq2 VGND_uq2 13.4169
R51 VGND_uq2 VGND_uq2 13.383
R52 VGND_uq2 VGND_uq2 12.9377
R53 VGND_uq2 VGND_uq2 12.9038
R54 w_200_0.n138 w_200_0.n137 12.8005
R55 VGND_uq2 w_200_0.n4 11.7346
R56 w_200_0.n7 VGND_uq2 11.7346
R57 w_200_0.n110 VGND_uq2 9.343
R58 w_200_0.n73 VGND_uq2 9.343
R59 VGND_uq2 w_200_0.n148 9.33435
R60 w_200_0.n21 VGND_uq2 7.19493
R61 w_200_0.n20 VGND_uq2 9.3005
R62 w_200_0.n137 VGND_uq2 9.3005
R63 w_200_0.n138 VGND_uq2 9.3005
R64 w_200_0.n149 VGND_uq2 7.15377
R65 w_200_0.n76 VGND_uq2 9.3005
R66 VGND_uq2 VGND 7.93251
R67 w_200_0.n100 w_200_0.n1 7.56446
R68 w_200_0.n108 w_200_0.n45 7.56446
R69 w_200_0.n71 w_200_0.n40 7.56446
R70 w_200_0.n84 w_200_0.n71 7.56446
R71 w_200_0.n106 w_200_0.n1 7.56446
R72 VGND_uq2 VGND 7.46454
R73 w_200_0.n45 VGND_uq2 5.7847
R74 w_200_0.n107 w_200_0.n106 4.22742
R75 w_200_0.n103 VGND_uq2 4.11618
R76 w_200_0.n108 w_200_0.n107 3.33754
R77 w_200_0.n85 w_200_0.n84 3.33754
R78 w_200_0.n112 VGND_uq2 2.44766
R79 w_200_0.n0 w_200_0.n5 2.17498
R80 VGND_uq2 VGND_uq2 1.8452
R81 w_200_0.n7 w_200_0.n6 1.86508
R82 VGND_uq2 VGND_uq2 1.26378
R83 w_200_0.n6 w_200_0.n5 1.2505
R84 VGND_uq2 VGND_uq2 1.20278
R85 VGND_uq2 VGND_uq2 1.13918
R86 VGND_uq2 VGND_uq2 0.937281
R87 VGND_uq2 VGND_uq2 0.858175
R88 VGND_uq2 VGND_uq2 0.825434
R89 VGND_uq2 VGND_uq2 0.825202
R90 VGND_uq2 VGND_uq2 0.825177
R91 VGND_uq2 VGND_uq2 0.778472
R92 VGND_uq2 VGND_uq2 0.775564
R93 VGND_uq2 VGND_uq2 0.751592
R94 VGND_uq2 VGND_uq2 0.709288
R95 VGND_uq2 VGND_uq2 0.708096
R96 VGND_uq2 VGND_uq2 0.704095
R97 VGND_uq2 VGND_uq2 0.685154
R98 VGND_uq2 VGND_uq2 0.695712
R99 VGND_uq2 VGND_uq2 0.263521
R100 VGND_uq2 VGND_uq2 0.239084
R101 VGND_uq2 VGND_uq2 0.475069
R102 VGND_uq2 VGND_uq2 0.475425
R103 VGND_uq2 VGND_uq2 0.473716
R104 VGND_uq2 VGND_uq2 0.450602
R105 VGND_uq2 VGND_uq2 0.359875
R106 VGND_uq2 VGND_uq2 0.356694
R107 VGND_uq2 VGND_uq2 0.358767
R108 VGND_uq2 VGND_uq2 0.262219
R109 VGND_uq2 VGND_uq2 0.240083
R110 VGND_uq2 VGND_uq2 0.238651
R111 VGND_uq2 VGND_uq2 0.240083
R112 VGND_uq2 VGND_uq2 0.206229
R113 VGND_uq2 VGND_uq2 0.142427
R114 VGND_uq2 VGND_uq2 0.142427
R115 VGND_uq2 VGND_uq2 0.120292
R116 w_200_0.n149 VGND_uq2 27.6382
R117 VGND_uq2 VGND_uq2 8363.35
R118 w_200_0.n152 VGND_uq2 1205.42
R119 w_200_0.n94 w_200_0.n3 531.087
R120 w_200_0.n162 w_200_0.n16 11.1338
R121 w_200_0.n162 w_200_0.n6 3811.87
R122 w_200_0.n16 w_200_0.n6 1501.43
R123 w_200_0.n158 w_200_0.n6 1337.14
R124 VGND_uq2 w_200_0.n22 1205.72
R125 VGND_uq2 w_200_0.n21 474.048
R126 w_200_0.n137 VGND_uq2 32.5812
R127 w_200_0.n137 VGND_uq2 543.302
R128 VGND_uq2 w_200_0.n151 7.62446
R129 VGND_uq2 w_200_0.n151 44.2194
R130 w_200_0.n151 VGND_uq2 717.479
R131 w_200_0.n150 VGND_uq2 32.6276
R132 w_200_0.n173 w_200_0.n8 349.709
R133 w_200_0.n172 w_200_0.n9 404.961
R134 w_200_0.n170 w_200_0.n10 337.813
R135 w_200_0.n168 w_200_0.n12 310.428
R136 w_200_0.n166 w_200_0.n11 403.577
R137 w_200_0.n165 w_200_0.n14 403.341
R138 w_200_0.n163 w_200_0.n15 387.533
R139 w_200_0.n161 w_200_0.n159 77.4325
R140 w_200_0.n157 w_200_0.n18 300.908
R141 w_200_0.n156 w_200_0.n18 272.204
R142 w_200_0.n153 w_200_0.n19 291.274
R143 w_200_0.n152 w_200_0.n19 400.651
R144 VGND_uq2 VGND_uq2 4900.03
R145 VGND_uq2 w_200_0.n149 6332.43
R146 VGND_uq2 w_200_0.n149 2621.5
R147 VGND_uq2 w_200_0.n20 1951.57
R148 VGND_uq2 VGND_uq2 9136.78
R149 VGND_uq2 VGND_uq2 7945.89
R150 VGND_uq2 w_200_0.n21 1988.65
R151 VGND_uq2 w_200_0.n21 15060.7
R152 VGND_uq2 VGND_uq2 4371.87
R153 w_200_0.n20 VGND_uq2 32.6284
R154 w_200_0.n21 VGND_uq2 31.1582
R155 VGND_uq2 VGND_uq2 14482
R156 w_200_0.n22 w_200_0.n23 419.805
R157 w_200_0.n146 w_200_0.n24 475.635
R158 w_200_0.n144 w_200_0.n25 479.536
R159 w_200_0.n142 w_200_0.n26 460.11
R160 w_200_0.n140 w_200_0.n27 364.233
R161 w_200_0.n139 w_200_0.n60 553.028
R162 VGND_uq2 w_200_0.n34 336.442
R163 VGND_uq2 w_200_0.n138 3348.23
R164 w_200_0.n34 w_200_0.n138 2053.58
R165 w_200_0.n34 VGND_uq2 434.38
R166 w_200_0.n34 w_200_0.n137 1824.34
R167 VGND_uq2 w_200_0.n137 4322.88
R168 w_200_0.n125 w_200_0.n29 465.897
R169 w_200_0.n123 w_200_0.n30 479.517
R170 w_200_0.n121 w_200_0.n31 464.656
R171 VGND_uq2 w_200_0.n32 655.761
R172 w_200_0.n119 w_200_0.n33 456.281
R173 w_200_0.n115 w_200_0.n38 472.604
R174 w_200_0.n82 w_200_0.n42 641.917
R175 w_200_0.n109 w_200_0.n44 620.966
R176 w_200_0.n102 w_200_0.n49 684.759
R177 w_200_0.n100 w_200_0.n48 7.58756
R178 w_200_0.n100 w_200_0.n47 950.035
R179 w_200_0.n48 w_200_0.n47 1534.67
R180 w_200_0.n93 w_200_0.n53 383.255
R181 w_200_0.n86 w_200_0.n55 527.514
R182 w_200_0.n89 w_200_0.n88 13.4878
R183 w_200_0.n89 w_200_0.n55 516.705
R184 w_200_0.n88 w_200_0.n55 1130.02
R185 w_200_0.n67 w_200_0.n69 108.588
R186 w_200_0.n68 w_200_0.n57 470.099
R187 w_200_0.n65 w_200_0.n58 464.969
R188 w_200_0.n63 w_200_0.n59 502.175
R189 w_200_0.n60 w_200_0.n62 549.13
R190 w_200_0.n64 w_200_0.n59 365.337
R191 w_200_0.n66 w_200_0.n58 352.062
R192 w_200_0.n67 w_200_0.n57 378.49
R193 w_200_0.n69 w_200_0.n35 422.164
R194 w_200_0.n70 w_200_0.n36 478.557
R195 w_200_0.n70 w_200_0.n39 366.88
R196 w_200_0.n73 w_200_0.n80 41.7113
R197 w_200_0.n73 w_200_0.n74 573.37
R198 w_200_0.n80 w_200_0.n74 874.663
R199 w_200_0.n76 w_200_0.n56 427.175
R200 w_200_0.n77 w_200_0.n46 507.332
R201 w_200_0.n77 w_200_0.n41 507.332
R202 w_200_0.n79 w_200_0.n78 507.332
R203 w_200_0.n79 w_200_0.n75 524.163
R204 w_200_0.n80 w_200_0.n81 35.1124
R205 w_200_0.n80 VGND_uq2 79.213
R206 w_200_0.n81 VGND_uq2 15.2871
R207 w_200_0.n81 w_200_0.n82 52.3208
R208 w_200_0.n81 w_200_0.n83 1195.6
R209 w_200_0.n82 w_200_0.n83 742.322
R210 w_200_0.n88 w_200_0.n87 855.91
R211 w_200_0.n90 w_200_0.n54 368.567
R212 w_200_0.n92 w_200_0.n53 349.808
R213 w_200_0.n94 w_200_0.n93 22.3324
R214 w_200_0.n95 w_200_0.n52 316.154
R215 w_200_0.n98 w_200_0.n97 42.3942
R216 w_200_0.n98 VGND_uq2 38.9651
R217 w_200_0.n97 VGND_uq2 25.6601
R218 w_200_0.n102 VGND_uq2 25.4527
R219 w_200_0.n48 w_200_0.n103 13.5106
R220 w_200_0.n48 w_200_0.n104 1130.02
R221 w_200_0.n103 w_200_0.n104 1227.44
R222 w_200_0.n105 w_200_0.n47 472.813
R223 w_200_0.n110 w_200_0.n109 33.0665
R224 w_200_0.n110 w_200_0.n43 755.61
R225 w_200_0.n109 w_200_0.n43 1135.71
R226 w_200_0.n113 w_200_0.n40 303.783
R227 w_200_0.n113 w_200_0.n112 303.783
R228 w_200_0.n40 w_200_0.n112 7.65982
R229 w_200_0.n119 w_200_0.n32 459.647
R230 w_200_0.n120 w_200_0.n31 344.082
R231 w_200_0.n122 w_200_0.n30 362.485
R232 w_200_0.n124 w_200_0.n29 325.113
R233 VGND_uq2 w_200_0.n28 461.942
R234 w_200_0.n134 w_200_0.n126 476.808
R235 w_200_0.n132 w_200_0.n127 479.536
R236 w_200_0.n130 w_200_0.n128 461.19
R237 w_200_0.n129 w_200_0.n128 335.827
R238 w_200_0.n131 w_200_0.n127 362.486
R239 w_200_0.n133 w_200_0.n126 329.199
R240 w_200_0.n135 w_200_0.n28 325.704
R241 w_200_0.n136 VGND_uq2 297.954
R242 VGND_uq2 w_200_0.n136 6411.26
R243 VGND_uq2 w_200_0.n136 1482.41
R244 w_200_0.n138 VGND_uq2 30.7498
R245 VGND_uq2 w_200_0.n139 6641.82
R246 w_200_0.n139 VGND_uq2 1470.31
R247 VGND_uq2 w_200_0.n139 206.852
R248 VGND_uq2 w_200_0.n27 918.307
R249 w_200_0.n139 w_200_0.n27 611.808
R250 w_200_0.n141 w_200_0.n26 338.656
R251 w_200_0.n143 w_200_0.n25 362.486
R252 w_200_0.n145 w_200_0.n24 329.122
R253 w_200_0.n147 w_200_0.n23 286.176
R254 VGND_uq2 VGND_uq2 9513.49
R255 VGND_uq2 VGND_uq2 3888.47
R256 VGND_uq2 VGND_uq2 2196.74
R257 VGND_uq2 w_200_0.n148 4209.6
R258 VGND_uq2 w_200_0.n148 2549.15
R259 w_200_0.n148 VGND_uq2 31.1745
R260 VGND_uq2 VGND_uq2 8871.24
R261 VGND_uq2 w_200_0.n150 11569.7
R262 VGND_uq2 w_200_0.n150 2361.61
R263 VGND_uq2 VGND_uq2 10269
R264 VGND_uq2 w_200_0.n151 13350.6
R265 VGND_uq2 w_200_0.n151 2320.93
R266 w_200_0.n155 w_200_0.n154 268.577
R267 w_200_0.n159 w_200_0.n17 364.781
R268 w_200_0.n16 w_200_0.n160 390.942
R269 w_200_0.n162 w_200_0.n15 414.337
R270 w_200_0.n164 w_200_0.n5 1215.93
R271 w_200_0.n166 w_200_0.n165 76.3396
R272 w_200_0.n169 w_200_0.n10 341.265
R273 w_200_0.n171 w_200_0.n9 378.634
R274 w_200_0.n173 w_200_0.n172 76.3366
R275 VGND_uq2 VGND_uq2 3065.14
R276 VGND_uq2 VGND_uq2 41817
R277 w_200_0.n20 VGND_uq2 529.374
R278 w_200_0.n21 VGND_uq2 2260.2
R279 VGND_uq2 VGND_uq2 2473.72
R280 w_200_0.n150 VGND_uq2 529.946
R281 w_200_0.n13 w_200_0.n12 336.724
R282 w_200_0.n35 w_200_0.n36 603.107
R283 w_200_0.n35 w_200_0.n117 1585.25
R284 w_200_0.n36 w_200_0.n117 1600.95
R285 w_200_0.n39 w_200_0.n113 808.794
R286 w_200_0.n46 w_200_0.n49 1246.43
R287 w_200_0.n46 w_200_0.n106 1915.88
R288 w_200_0.n49 w_200_0.n106 1915.88
R289 w_200_0.n107 w_200_0.n38 543.399
R290 w_200_0.n44 w_200_0.n98 1858.52
R291 w_200_0.n109 w_200_0.n98 81.3306
R292 w_200_0.n109 w_200_0.n50 1858.52
R293 w_200_0.n98 w_200_0.n50 909.364
R294 w_200_0.n62 w_200_0.n63 998.716
R295 w_200_0.n60 w_200_0.n63 1233.12
R296 w_200_0.n67 w_200_0.n68 1575.55
R297 w_200_0.n68 VGND_uq2 987.173
R298 w_200_0.n36 w_200_0.n39 630.952
R299 w_200_0.n36 w_200_0.n37 1616.47
R300 w_200_0.n39 w_200_0.n37 936.345
R301 w_200_0.n70 w_200_0.n37 4182.33
R302 w_200_0.n75 w_200_0.n78 1318.72
R303 w_200_0.n75 w_200_0.n84 1958
R304 w_200_0.n78 w_200_0.n84 1958
R305 w_200_0.n79 w_200_0.n84 2907.18
R306 w_200_0.n83 w_200_0.n42 1318.72
R307 w_200_0.n83 w_200_0.n71 1958
R308 w_200_0.n42 w_200_0.n71 1958
R309 w_200_0.n82 w_200_0.n71 2907.18
R310 w_200_0.n41 w_200_0.n46 1318.72
R311 w_200_0.n41 w_200_0.n45 1958
R312 w_200_0.n46 w_200_0.n45 1958
R313 w_200_0.n77 w_200_0.n45 2907.18
R314 w_200_0.n78 w_200_0.n41 1246.43
R315 w_200_0.n78 w_200_0.n40 1915.88
R316 w_200_0.n41 w_200_0.n40 1915.88
R317 w_200_0.n56 w_200_0.n75 1262.87
R318 w_200_0.n56 w_200_0.n2 734.735
R319 w_200_0.n75 w_200_0.n2 886.533
R320 w_200_0.n54 w_200_0.n91 319.402
R321 w_200_0.n52 w_200_0.n94 283.531
R322 w_200_0.n47 w_200_0.n1 1215.97
R323 w_200_0.n43 w_200_0.n44 1318.72
R324 w_200_0.n43 w_200_0.n108 1958
R325 w_200_0.n44 w_200_0.n108 1958
R326 w_200_0.n109 w_200_0.n108 2907.18
R327 w_200_0.n42 w_200_0.n110 1673.29
R328 w_200_0.n82 w_200_0.n110 73.2249
R329 w_200_0.n82 w_200_0.n111 2322.12
R330 w_200_0.n110 w_200_0.n111 818.732
R331 w_200_0.n37 w_200_0.n113 1895.51
R332 w_200_0.n37 w_200_0.n114 855.505
R333 w_200_0.n39 w_200_0.n114 2518.7
R334 w_200_0.n113 w_200_0.n114 2174.26
R335 w_200_0.n33 w_200_0.n116 1380.62
R336 w_200_0.n32 w_200_0.n33 630.952
R337 w_200_0.n32 w_200_0.n118 1632.47
R338 w_200_0.n33 w_200_0.n118 1616.47
R339 w_200_0.n119 w_200_0.n118 4182.33
R340 VGND_uq2 VGND_uq2 9768.11
R341 VGND_uq2 VGND_uq2 2040.69
R342 VGND_uq2 VGND_uq2 8736.58
R343 VGND_uq2 VGND_uq2 30225.6
R344 VGND_uq2 VGND_uq2 1919.87
R345 VGND_uq2 VGND_uq2 2971.36
R346 VGND_uq2 VGND_uq2 9744.56
R347 VGND_uq2 VGND_uq2 11364.7
R348 VGND_uq2 VGND_uq2 2260.49
R349 VGND_uq2 VGND_uq2 37410.6
R350 VGND_uq2 VGND_uq2 7443.31
R351 w_200_0.n148 w_200_0.n149 6043
R352 w_200_0.n149 VGND_uq2 101.859
R353 VGND_uq2 VGND_uq2 14232.1
R354 VGND_uq2 VGND_uq2 3761.72
R355 VGND_uq2 VGND_uq2 26045.2
R356 w_200_0.n17 w_200_0.n158 335.704
R357 w_200_0.n14 w_200_0.n164 367.365
R358 w_200_0.n11 w_200_0.n167 332.938
R359 w_200_0.n166 w_200_0.n167 1344.55
R360 w_200_0.n11 w_200_0.n5 57901.1
R361 w_200_0.n167 w_200_0.n5 1402.47
R362 w_200_0.n171 w_200_0.n169 28.0126
R363 w_200_0.n8 w_200_0.n174 322.397
R364 w_200_0.n173 w_200_0.n174 1033.42
R365 w_200_0.n8 w_200_0.n0 61493.5
R366 w_200_0.n174 w_200_0.n0 1222.34
R367 w_200_0.n13 w_200_0.n168 903.87
R368 w_200_0.n11 w_200_0.n13 945.39
R369 w_200_0.n166 w_200_0.n13 169.796
R370 w_200_0.n159 w_200_0.n160 1630.44
R371 VGND_uq2 VGND_uq2 203976
R372 VGND_uq2 VGND_uq2 8304.88
R373 VGND_uq2 VGND_uq2 2185.09
R374 VGND_uq2 VGND_uq2 30305
R375 VGND_uq2 VGND_uq2 11607.7
R376 VGND_uq2 VGND_uq2 10794.5
R377 w_200_0.n107 w_200_0.n115 342.863
R378 w_200_0.n61 w_200_0.n60 2744.08
R379 w_200_0.n63 w_200_0.n64 2880.75
R380 w_200_0.n63 w_200_0.n61 3166.08
R381 w_200_0.n59 w_200_0.n61 1129.23
R382 w_200_0.n64 w_200_0.n61 172.018
R383 w_200_0.n64 w_200_0.n65 1684.19
R384 w_200_0.n65 w_200_0.n59 1384.57
R385 w_200_0.n65 w_200_0.n63 2105.36
R386 w_200_0.n65 w_200_0.n66 2289.76
R387 w_200_0.n58 w_200_0.n64 929.741
R388 w_200_0.n66 w_200_0.n64 169.47
R389 w_200_0.n57 w_200_0.n66 791.26
R390 w_200_0.n67 w_200_0.n66 168.714
R391 VGND_uq2 w_200_0.n35 1980.89
R392 VGND_uq2 w_200_0.n69 4074
R393 w_200_0.n68 w_200_0.n35 2658.45
R394 w_200_0.n68 w_200_0.n69 3849.67
R395 w_200_0.n117 w_200_0.n70 9396.33
R396 w_200_0.n117 w_200_0.n69 9396.33
R397 w_200_0.n36 w_200_0.n69 1564.36
R398 w_200_0.n70 w_200_0.n35 1549.02
R399 w_200_0.n70 w_200_0.n69 177.306
R400 w_200_0.n113 w_200_0.n70 3485.43
R401 w_200_0.n106 w_200_0.n77 6276.49
R402 w_200_0.n106 w_200_0.n102 6276.49
R403 w_200_0.n46 w_200_0.n102 1602.64
R404 w_200_0.n77 w_200_0.n49 1602.64
R405 w_200_0.n77 w_200_0.n102 112.957
R406 w_200_0.n40 w_200_0.n79 6276.49
R407 w_200_0.n40 w_200_0.n77 6276.49
R408 w_200_0.n78 w_200_0.n77 1602.64
R409 w_200_0.n79 w_200_0.n41 1602.64
R410 w_200_0.n79 w_200_0.n77 112.957
R411 w_200_0.n2 w_200_0.n79 6984.96
R412 w_200_0.n2 w_200_0.n76 5568.55
R413 w_200_0.n75 w_200_0.n76 1421.88
R414 w_200_0.n79 w_200_0.n56 2101.51
R415 w_200_0.n79 w_200_0.n76 100.218
R416 w_200_0.n85 w_200_0.n86 335.173
R417 w_200_0.n89 w_200_0.n76 261.036
R418 w_200_0.n89 w_200_0.n73 261.036
R419 w_200_0.n91 w_200_0.n90 1003.54
R420 w_200_0.n91 w_200_0.n92 1364.92
R421 w_200_0.n54 w_200_0.n92 961.436
R422 w_200_0.n90 w_200_0.n92 169.861
R423 w_200_0.n92 w_200_0.n93 1646.55
R424 w_200_0.n91 w_200_0.n53 906.734
R425 w_200_0.n91 w_200_0.n93 46.2608
R426 w_200_0.n103 w_200_0.n97 1021.88
R427 w_200_0.n103 w_200_0.n51 2834.74
R428 w_200_0.n116 w_200_0.n115 5134.75
R429 w_200_0.n116 w_200_0.n119 6885.32
R430 w_200_0.n115 w_200_0.n33 1147.57
R431 w_200_0.n115 w_200_0.n119 174.51
R432 w_200_0.n32 w_200_0.n120 956.298
R433 w_200_0.n119 w_200_0.n120 206.577
R434 w_200_0.n120 w_200_0.n121 2210.36
R435 w_200_0.n121 w_200_0.n122 1684.19
R436 w_200_0.n31 w_200_0.n122 929.741
R437 w_200_0.n120 w_200_0.n122 169.47
R438 w_200_0.n122 w_200_0.n123 2610.67
R439 w_200_0.n121 w_200_0.n30 1384.57
R440 w_200_0.n121 w_200_0.n123 2105.36
R441 w_200_0.n123 w_200_0.n124 1683.66
R442 w_200_0.n30 w_200_0.n124 929.718
R443 w_200_0.n122 w_200_0.n124 169.47
R444 w_200_0.n124 w_200_0.n125 1667.68
R445 w_200_0.n123 w_200_0.n29 1381.92
R446 w_200_0.n123 w_200_0.n125 2115.49
R447 w_200_0.n125 w_200_0.n136 1468.59
R448 w_200_0.n130 w_200_0.n129 2064.05
R449 w_200_0.n130 w_200_0.n131 1684.19
R450 w_200_0.n128 w_200_0.n131 929.741
R451 w_200_0.n129 w_200_0.n131 169.47
R452 w_200_0.n131 w_200_0.n132 2610.89
R453 w_200_0.n130 w_200_0.n127 1384.57
R454 w_200_0.n130 w_200_0.n132 2105.36
R455 w_200_0.n132 w_200_0.n133 1684.19
R456 w_200_0.n127 w_200_0.n133 929.741
R457 w_200_0.n131 w_200_0.n133 169.47
R458 w_200_0.n133 w_200_0.n134 1907.73
R459 w_200_0.n132 w_200_0.n126 1384.57
R460 w_200_0.n132 w_200_0.n134 2105.36
R461 w_200_0.n134 w_200_0.n28 1883.65
R462 w_200_0.n134 VGND_uq2 1143.92
R463 VGND_uq2 w_200_0.n135 4701.37
R464 w_200_0.n136 w_200_0.n28 1157.71
R465 w_200_0.n136 w_200_0.n135 1176.01
R466 VGND_uq2 w_200_0.n140 1549.48
R467 w_200_0.n140 w_200_0.n141 157.981
R468 w_200_0.n141 w_200_0.n142 2085.53
R469 w_200_0.n142 w_200_0.n143 1684.19
R470 w_200_0.n26 w_200_0.n143 929.741
R471 w_200_0.n141 w_200_0.n143 169.47
R472 w_200_0.n143 w_200_0.n144 2610.89
R473 w_200_0.n142 w_200_0.n25 1384.57
R474 w_200_0.n142 w_200_0.n144 2105.36
R475 w_200_0.n144 w_200_0.n145 1684.19
R476 w_200_0.n25 w_200_0.n145 929.741
R477 w_200_0.n143 w_200_0.n145 169.47
R478 w_200_0.n145 w_200_0.n146 1891.69
R479 w_200_0.n144 w_200_0.n24 1384.57
R480 w_200_0.n144 w_200_0.n146 2105.36
R481 w_200_0.n146 w_200_0.n23 1645
R482 w_200_0.n146 w_200_0.n22 1334.77
R483 w_200_0.n22 w_200_0.n147 1639.04
R484 VGND_uq2 VGND_uq2 8598.14
R485 VGND_uq2 VGND_uq2 135440
R486 w_200_0.n152 w_200_0.n153 1511.16
R487 w_200_0.n156 w_200_0.n157 417.067
R488 w_200_0.n162 w_200_0.n161 5184.31
R489 w_200_0.n162 w_200_0.n163 2362.16
R490 w_200_0.n161 w_200_0.n15 1137.71
R491 w_200_0.n161 w_200_0.n163 171.655
R492 w_200_0.n163 w_200_0.n164 1369.12
R493 w_200_0.n15 w_200_0.n164 903.516
R494 w_200_0.n162 w_200_0.n164 46.1442
R495 w_200_0.n164 w_200_0.n165 2039.96
R496 w_200_0.n163 w_200_0.n14 962.069
R497 w_200_0.n163 w_200_0.n165 169.868
R498 w_200_0.n169 w_200_0.n170 1233.57
R499 w_200_0.n171 w_200_0.n10 2287.42
R500 w_200_0.n171 w_200_0.n170 1778.81
R501 w_200_0.n171 w_200_0.n172 2177.34
R502 w_200_0.n170 w_200_0.n9 959.775
R503 w_200_0.n170 w_200_0.n172 170.386
R504 w_200_0.n172 w_200_0.n174 2150.87
R505 w_200_0.n9 w_200_0.n174 911.139
R506 w_200_0.n171 w_200_0.n174 46.2658
R507 w_200_0.n171 w_200_0.n8 7906.47
R508 w_200_0.n171 w_200_0.n173 8831.18
R509 w_200_0.n8 w_200_0.n9 3430.56
R510 w_200_0.n8 w_200_0.n172 3846.61
R511 w_200_0.n9 w_200_0.n173 3831.79
R512 w_200_0.n172 w_200_0.n10 8618.65
R513 w_200_0.n172 w_200_0.n169 11960.3
R514 w_200_0.n10 w_200_0.n9 3281.65
R515 w_200_0.n9 w_200_0.n169 4554.02
R516 w_200_0.n170 w_200_0.n168 2035.23
R517 w_200_0.n168 w_200_0.n10 1294.91
R518 w_200_0.n166 w_200_0.n168 7167.23
R519 w_200_0.n166 w_200_0.n12 8253.09
R520 w_200_0.n168 w_200_0.n11 1323.36
R521 w_200_0.n11 w_200_0.n12 2998.58
R522 w_200_0.n165 w_200_0.n162 19643.5
R523 w_200_0.n165 w_200_0.n15 8478.46
R524 w_200_0.n162 w_200_0.n14 7503.45
R525 w_200_0.n14 w_200_0.n15 3238.62
R526 w_200_0.n163 w_200_0.n160 3684.69
R527 w_200_0.n163 w_200_0.n16 9628.83
R528 w_200_0.n162 w_200_0.n160 3770.73
R529 w_200_0.n15 w_200_0.n160 1407.49
R530 w_200_0.n15 w_200_0.n16 3678.04
R531 w_200_0.n161 w_200_0.n16 3019.28
R532 w_200_0.n157 w_200_0.n17 1417.33
R533 w_200_0.n157 w_200_0.n158 1217.6
R534 w_200_0.n22 w_200_0.n145 9782.17
R535 w_200_0.n22 w_200_0.n24 8402.62
R536 w_200_0.n145 w_200_0.n23 1556.81
R537 w_200_0.n23 w_200_0.n24 2217.02
R538 w_200_0.n146 w_200_0.n143 37960
R539 w_200_0.n146 w_200_0.n25 14500.1
R540 w_200_0.n143 w_200_0.n24 6836.18
R541 w_200_0.n24 w_200_0.n25 2611.3
R542 w_200_0.n144 w_200_0.n141 37960
R543 w_200_0.n144 w_200_0.n26 14500.1
R544 w_200_0.n141 w_200_0.n25 6836.18
R545 w_200_0.n25 w_200_0.n26 2611.3
R546 w_200_0.n142 w_200_0.n140 8004.69
R547 w_200_0.n140 w_200_0.n26 2616.62
R548 w_200_0.n136 w_200_0.n124 4651.24
R549 w_200_0.n136 w_200_0.n29 5413.5
R550 w_200_0.n125 w_200_0.n122 38142.7
R551 w_200_0.n125 w_200_0.n30 14569.8
R552 w_200_0.n122 w_200_0.n29 6832.59
R553 w_200_0.n29 w_200_0.n30 2609.93
R554 w_200_0.n123 w_200_0.n120 37960
R555 w_200_0.n123 w_200_0.n31 14500.1
R556 w_200_0.n120 w_200_0.n30 6836.18
R557 w_200_0.n30 w_200_0.n31 2611.3
R558 w_200_0.n121 w_200_0.n119 23727.9
R559 w_200_0.n121 w_200_0.n32 6466.52
R560 w_200_0.n119 w_200_0.n31 6254.11
R561 w_200_0.n31 w_200_0.n32 2206.34
R562 w_200_0.n119 w_200_0.n114 3711.24
R563 w_200_0.n119 w_200_0.n37 9508.03
R564 w_200_0.n116 w_200_0.n114 3798.03
R565 w_200_0.n33 w_200_0.n114 1444.96
R566 w_200_0.n33 w_200_0.n37 3701.92
R567 w_200_0.n115 w_200_0.n37 4177.95
R568 w_200_0.n38 w_200_0.n1 791787
R569 w_200_0.n115 w_200_0.n1 165627
R570 w_200_0.n115 w_200_0.n47 44073.2
R571 w_200_0.n47 w_200_0.n107 1079.44
R572 w_200_0.n92 w_200_0.n52 1699.69
R573 w_200_0.n92 w_200_0.n94 3925.85
R574 w_200_0.n52 w_200_0.n53 2580.4
R575 w_200_0.n52 w_200_0.n93 3312.88
R576 w_200_0.n53 w_200_0.n94 3311.72
R577 w_200_0.n93 w_200_0.n90 19650.8
R578 w_200_0.n93 w_200_0.n54 7506.26
R579 w_200_0.n90 w_200_0.n53 8526.35
R580 w_200_0.n53 w_200_0.n54 3256.91
R581 w_200_0.n35 w_200_0.n57 3822.81
R582 w_200_0.n35 w_200_0.n67 3672.81
R583 VGND_uq2 w_200_0.n57 7388.45
R584 VGND_uq2 w_200_0.n67 7098.54
R585 w_200_0.n57 w_200_0.n69 4514.74
R586 w_200_0.n67 w_200_0.n65 21054.1
R587 w_200_0.n67 w_200_0.n58 5603.94
R588 w_200_0.n65 w_200_0.n57 4554.81
R589 w_200_0.n57 w_200_0.n58 1634.19
R590 w_200_0.n66 w_200_0.n63 37960
R591 w_200_0.n66 w_200_0.n59 6836.18
R592 w_200_0.n63 w_200_0.n58 14500.1
R593 w_200_0.n58 w_200_0.n59 2611.3
R594 w_200_0.n64 w_200_0.n60 46183
R595 w_200_0.n64 w_200_0.n62 3440.39
R596 w_200_0.n59 w_200_0.n60 17693.5
R597 w_200_0.n59 w_200_0.n62 1318.07
R598 w_200_0.n62 w_200_0.n139 8178.49
R599 w_200_0.n62 w_200_0.n27 1369.21
R600 w_200_0.n61 w_200_0.n139 11244.4
R601 w_200_0.n61 w_200_0.n27 1119.31
R602 w_200_0.n60 w_200_0.n27 1767.87
R603 w_200_0.n139 w_200_0.n140 15090.5
R604 w_200_0.n60 w_200_0.n140 6185.13
R605 w_200_0.n62 w_200_0.n140 3632.36
R606 w_200_0.n61 w_200_0.n140 171.571
R607 w_200_0.n65 w_200_0.n68 7081.23
R608 w_200_0.n58 w_200_0.n68 4656.89
R609 w_200_0.n66 w_200_0.n68 5664.64
R610 w_200_0.n92 w_200_0.n95 299.64
R611 w_200_0.n53 w_200_0.n95 1688.91
R612 w_200_0.n93 w_200_0.n95 3910.12
R613 w_200_0.n94 w_200_0.n95 338.18
R614 w_200_0.n4 w_200_0.n96 114.531
R615 w_200_0.n107 w_200_0.n105 413.779
R616 w_200_0.n38 w_200_0.n105 44509.9
R617 w_200_0.n115 w_200_0.n105 9310.56
R618 w_200_0.n1 w_200_0.n105 3612.33
R619 w_200_0.n121 VGND_uq2 5100.65
R620 w_200_0.n31 VGND_uq2 3239.94
R621 w_200_0.n120 VGND_uq2 3480.84
R622 w_200_0.n119 VGND_uq2 11168
R623 w_200_0.n124 w_200_0.n135 279.863
R624 w_200_0.n29 w_200_0.n135 1307.09
R625 w_200_0.n125 w_200_0.n135 1712.81
R626 VGND_uq2 w_200_0.n133 8383.51
R627 VGND_uq2 w_200_0.n126 7201.21
R628 w_200_0.n133 w_200_0.n28 1582.7
R629 w_200_0.n28 w_200_0.n126 2278.83
R630 w_200_0.n134 w_200_0.n131 37960
R631 w_200_0.n134 w_200_0.n127 14500.1
R632 w_200_0.n131 w_200_0.n126 6836.18
R633 w_200_0.n126 w_200_0.n127 2611.3
R634 w_200_0.n132 w_200_0.n129 37960
R635 w_200_0.n132 w_200_0.n128 14500.1
R636 w_200_0.n129 w_200_0.n127 6836.18
R637 w_200_0.n127 w_200_0.n128 2611.3
R638 w_200_0.n128 w_200_0.n19 2889.37
R639 w_200_0.n129 w_200_0.n19 930.057
R640 w_200_0.n19 w_200_0.n130 7639.11
R641 w_200_0.n133 w_200_0.n135 297.495
R642 w_200_0.n126 w_200_0.n135 1638.66
R643 w_200_0.n134 w_200_0.n135 3123.08
R644 w_200_0.n145 w_200_0.n147 297.425
R645 w_200_0.n24 w_200_0.n147 1636.2
R646 w_200_0.n146 w_200_0.n147 3067.66
R647 w_200_0.n153 VGND_uq2 1744.83
R648 w_200_0.n19 VGND_uq2 13703.3
R649 w_200_0.n152 VGND_uq2 32433.5
R650 w_200_0.n155 w_200_0.n7 286.07
R651 w_200_0.n154 w_200_0.n7 895.606
R652 w_200_0.n155 VGND_uq2 858.249
R653 w_200_0.n154 VGND_uq2 941.202
R654 w_200_0.n157 w_200_0.n159 284.125
R655 w_200_0.n158 w_200_0.n159 1214.47
R656 w_200_0.n160 w_200_0.n17 1422.4
R657 w_200_0.n161 w_200_0.n17 7791.64
R658 w_200_0.n17 w_200_0.n16 1357.58
R659 w_200_0.n159 w_200_0.n16 3926.62
R660 w_200_0.n165 w_200_0.n167 2159.82
R661 w_200_0.n14 w_200_0.n167 907.949
R662 w_200_0.n164 w_200_0.n167 46.1956
R663 w_200_0.n168 w_200_0.n169 55.9888
R664 w_200_0.n91 w_200_0.n3 1153.06
R665 w_200_0.n76 w_200_0.n88 2136.58
R666 w_200_0.n89 w_200_0.n74 4981.96
R667 w_200_0.n73 w_200_0.n88 2136.58
R668 w_200_0.n74 w_200_0.n88 666.588
R669 w_200_0.n74 w_200_0.n56 91880.8
R670 w_200_0.n89 w_200_0.n56 4981.96
R671 w_200_0.n56 w_200_0.n88 666.588
R672 w_200_0.n51 VGND_uq2 5809.86
R673 w_200_0.n97 VGND_uq2 188.429
R674 w_200_0.n103 VGND_uq2 148.29
R675 w_200_0.n130 w_200_0.n152 7186.21
R676 w_200_0.n129 w_200_0.n152 3169.33
R677 w_200_0.n128 w_200_0.n152 4141.57
R678 w_200_0.n130 w_200_0.n153 15159.9
R679 w_200_0.n128 w_200_0.n153 4630.4
R680 w_200_0.n129 w_200_0.n153 219.325
R681 w_200_0.n87 w_200_0.n56 149214
R682 w_200_0.n87 w_200_0.n2 761.255
R683 w_200_0.n87 w_200_0.n74 149214
R684 w_200_0.n88 w_200_0.n2 15.4081
R685 w_200_0.n2 w_200_0.n74 739.388
R686 w_200_0.n74 w_200_0.n72 1318.72
R687 w_200_0.n72 w_200_0.n80 1958
R688 w_200_0.n72 w_200_0.n2 894.534
R689 w_200_0.n80 w_200_0.n2 2907.18
R690 w_200_0.n2 w_200_0.n85 11.8638
R691 w_200_0.n75 w_200_0.n85 920.366
R692 w_200_0.n75 w_200_0.n72 127377
R693 w_200_0.n85 w_200_0.n72 920.366
R694 w_200_0.n85 w_200_0.n87 1446.34
R695 w_200_0.n86 w_200_0.n2 2941.93
R696 w_200_0.n169 w_200_0.n13 3675.37
R697 w_200_0.n169 w_200_0.n12 3847.46
R698 w_200_0.n10 w_200_0.n13 1922.87
R699 w_200_0.n10 w_200_0.n12 4412.79
R700 w_200_0.n170 w_200_0.n13 373.618
R701 w_200_0.n170 w_200_0.n12 1940.09
R702 w_200_0.n164 w_200_0.n11 7911.43
R703 w_200_0.n164 w_200_0.n166 8836.73
R704 w_200_0.n11 w_200_0.n14 3411.28
R705 w_200_0.n11 w_200_0.n165 3855.11
R706 w_200_0.n14 w_200_0.n166 3810.25
R707 w_200_0.n168 w_200_0.n5 8062.14
R708 w_200_0.n168 w_200_0.n167 69.2007
R709 w_200_0.n12 w_200_0.n5 193256
R710 w_200_0.n12 w_200_0.n167 1658.79
R711 w_200_0.n13 w_200_0.n5 266855
R712 w_200_0.n13 w_200_0.n167 2290.51
R713 w_200_0.n16 w_200_0.n158 59.7297
R714 w_200_0.n161 w_200_0.n158 12912.2
R715 w_200_0.n160 w_200_0.n158 1362.16
R716 w_200_0.n6 w_200_0.n17 111151
R717 w_200_0.n159 w_200_0.n18 8864.17
R718 w_200_0.n159 w_200_0.n156 3782.44
R719 w_200_0.n158 w_200_0.n18 3488.68
R720 w_200_0.n158 w_200_0.n156 48.9544
R721 w_200_0.n17 w_200_0.n18 13379.6
R722 w_200_0.n17 w_200_0.n156 4263.97
R723 w_200_0.n26 w_200_0.n27 6451.86
R724 w_200_0.n26 VGND_uq2 3641.13
R725 w_200_0.n142 w_200_0.n27 16462
R726 w_200_0.n142 VGND_uq2 6758.17
R727 w_200_0.n141 w_200_0.n27 3347.38
R728 w_200_0.n141 VGND_uq2 2765.64
R729 w_200_0.n29 w_200_0.n28 10294.2
R730 w_200_0.n29 VGND_uq2 206794
R731 w_200_0.n124 w_200_0.n28 7342.67
R732 w_200_0.n124 VGND_uq2 147502
R733 w_200_0.n28 w_200_0.n125 6450.97
R734 VGND_uq2 w_200_0.n125 129589
R735 w_200_0.n173 w_200_0.n0 211170
R736 w_200_0.n3 w_200_0.n52 11817.1
R737 w_200_0.n3 w_200_0.n90 81152.6
R738 w_200_0.n3 w_200_0.n54 53945.5
R739 w_200_0.n174 VGND_uq2 71.2788
R740 w_200_0.n8 VGND_uq2 1104.05
R741 w_200_0.n173 VGND_uq2 1689.26
R742 VGND_uq2 w_200_0.n0 1192.18
R743 w_200_0.n105 VGND_uq2 966.942
R744 w_200_0.n104 VGND_uq2 855.1
R745 w_200_0.n155 w_200_0.n153 926.189
R746 w_200_0.n154 w_200_0.n153 5543.4
R747 w_200_0.n104 w_200_0.n174 6657.23
R748 w_200_0.n104 w_200_0.n173 4397.72
R749 w_200_0.n104 w_200_0.n8 9674.6
R750 w_200_0.n174 w_200_0.n105 2709.84
R751 w_200_0.n0 w_200_0.n105 176026
R752 w_200_0.n173 w_200_0.n105 359.868
R753 w_200_0.n8 w_200_0.n105 1748.19
R754 w_200_0.n91 w_200_0.n55 4476.21
R755 w_200_0.n91 w_200_0.n89 77.6852
R756 w_200_0.n3 w_200_0.n55 139113
R757 w_200_0.n3 w_200_0.n89 1301.06
R758 w_200_0.n54 w_200_0.n55 11827.5
R759 w_200_0.n54 w_200_0.n89 1324.83
R760 w_200_0.n90 w_200_0.n55 1401.33
R761 w_200_0.n90 w_200_0.n89 992.125
R762 w_200_0.n91 w_200_0.n86 4699.58
R763 w_200_0.n3 w_200_0.n86 192152
R764 w_200_0.n54 w_200_0.n86 8225.03
R765 w_200_0.n90 w_200_0.n86 283.639
R766 w_200_0.n89 w_200_0.n86 1732.97
R767 w_200_0.n7 w_200_0.n157 1801.6
R768 w_200_0.n7 w_200_0.n18 4255.6
R769 w_200_0.n154 w_200_0.n156 713.538
R770 w_200_0.n154 w_200_0.n157 5748.92
R771 w_200_0.n154 w_200_0.n18 9804.53
R772 w_200_0.n155 w_200_0.n156 2172.79
R773 w_200_0.n155 w_200_0.n157 15248.8
R774 w_200_0.n155 w_200_0.n18 28362.8
R775 w_200_0.n154 w_200_0.n19 68399.8
R776 w_200_0.n154 w_200_0.n152 180073
R777 w_200_0.n155 w_200_0.n19 11519.4
R778 w_200_0.n155 w_200_0.n152 30361.2
R779 w_200_0.n156 VGND_uq2 233.185
R780 w_200_0.n157 VGND_uq2 1903.87
R781 w_200_0.n18 VGND_uq2 3219.23
R782 w_200_0.n7 VGND_uq2 758.035
R783 VGND_uq2 VGND_uq2 20535.1
R784 VGND_uq2 VGND_uq2 112147
R785 VGND_uq2 VGND_uq2 2330
R786 w_200_0.n103 w_200_0.n101 4635.24
R787 w_200_0.n101 w_200_0.n48 1508.69
R788 w_200_0.n20 VGND_uq2 7234.65
R789 VGND_uq2 VGND_uq2 2597.7
R790 w_200_0.n70 w_200_0.n85 378.82
R791 w_200_0.n113 w_200_0.n85 2880.36
R792 w_200_0.n39 w_200_0.n85 933.236
R793 w_200_0.n48 VGND_uq2 3523.12
R794 w_200_0.n48 w_200_0.n102 5847.36
R795 w_200_0.n101 VGND_uq2 2372.84
R796 w_200_0.n103 VGND_uq2 430.438
R797 w_200_0.n103 w_200_0.n102 714.4
R798 w_200_0.n87 w_200_0.n70 99650.4
R799 w_200_0.n86 w_200_0.n70 9202.99
R800 w_200_0.n86 w_200_0.n39 46857.5
R801 w_200_0.n86 w_200_0.n113 182094
R802 VGND_uq2 VGND_uq2 57505.7
R803 VGND_uq2 VGND_uq2 17400.2
R804 VGND_uq2 VGND_uq2 6645.93
R805 VGND_uq2 VGND_uq2 2010.94
R806 w_200_0.n4 VGND_uq2 2919.67
R807 w_200_0.n96 VGND_uq2 3040.58
R808 w_200_0.n147 VGND_uq2 1417.79
R809 w_200_0.n23 VGND_uq2 14518
R810 w_200_0.n22 VGND_uq2 23233.1
R811 w_200_0.n4 w_200_0.n22 58131.8
R812 w_200_0.n4 w_200_0.n23 23411.2
R813 w_200_0.n4 w_200_0.n147 1972.22
R814 w_200_0.n96 w_200_0.n22 63783.6
R815 w_200_0.n96 w_200_0.n23 25875.4
R816 w_200_0.n96 w_200_0.n147 2188.78
R817 w_200_0.n22 VGND_uq2 95456.3
R818 w_200_0.n23 VGND_uq2 59338.1
R819 w_200_0.n147 VGND_uq2 5969.87
R820 w_200_0.n96 VGND_uq2 18540.3
R821 w_200_0.n4 w_200_0.n3 3.74812
R822 w_200_0.n96 w_200_0.n3 1430.28
R823 w_200_0.n96 w_200_0.n94 573.271
R824 w_200_0.n96 w_200_0.n95 1250.55
R825 w_200_0.n96 w_200_0.n52 7700.7
R826 w_200_0.n4 w_200_0.n94 1866.57
R827 w_200_0.n4 w_200_0.n95 4619.63
R828 w_200_0.n4 w_200_0.n52 25756.9
R829 w_200_0.n95 w_200_0.n3 3173.61
R830 VGND_uq2 VGND_uq2 864.962
R831 VGND_uq2.n136 VGND_uq2.n8 294.916
R832 VGND_uq2.n148 VGND_uq2.n0 1179.3
R833 VGND_uq2.n149 VGND_uq2.n0 1179.3
R834 VGND_uq2.n82 VGND_uq2.n81 408.589
R835 VGND_uq2.n51 VGND_uq2.n49 585
R836 VGND_uq2.n88 VGND_uq2.n52 585
R837 VGND_uq2.n87 VGND_uq2.n13 585
R838 VGND_uq2.n12 VGND_uq2.n3 585
R839 VGND_uq2.n162 VGND_uq2.n161 585
R840 VGND_uq2.n155 VGND_uq2.n11 585
R841 VGND_uq2.n165 VGND_uq2.n11 546.876
R842 VGND_uq2.n163 VGND_uq2.n162 585
R843 VGND_uq2.n164 VGND_uq2.n163 585
R844 VGND_uq2.n3 VGND_uq2.n2 585
R845 VGND_uq2.n87 VGND_uq2.n86 585
R846 VGND_uq2.n89 VGND_uq2.n88 585
R847 VGND_uq2.n90 VGND_uq2.n89 585
R848 VGND_uq2.n95 VGND_uq2.n50 585
R849 VGND_uq2.n91 VGND_uq2.n50 585
R850 VGND_uq2.n55 VGND_uq2.n49 585
R851 VGND_uq2.n84 VGND_uq2.n83 585
R852 VGND_uq2.n85 VGND_uq2.n84 585
R853 VGND_uq2.n157 VGND_uq2.n156 389.438
R854 VGND_uq2.n141 VGND_uq2.n140 373.755
R855 VGND_uq2.n65 VGND_uq2.n64 333.322
R856 VGND_uq2.n96 VGND_uq2.n47 585
R857 VGND_uq2.n46 VGND_uq2.n45 585
R858 VGND_uq2.n100 VGND_uq2.n41 585
R859 VGND_uq2.n101 VGND_uq2.n43 585
R860 VGND_uq2.n99 VGND_uq2.n44 585
R861 VGND_uq2.n97 VGND_uq2.n48 585
R862 VGND_uq2.n97 VGND_uq2.n45 510
R863 VGND_uq2.n100 VGND_uq2.n99 510
R864 VGND_uq2.n97 VGND_uq2.n96 505
R865 VGND_uq2.n99 VGND_uq2.n45 505
R866 VGND_uq2.n101 VGND_uq2.n100 505
R867 VGND_uq2.n163 VGND_uq2.n11 394
R868 VGND_uq2.n163 VGND_uq2.n2 394
R869 VGND_uq2.n89 VGND_uq2.n86 394
R870 VGND_uq2.n89 VGND_uq2.n50 394
R871 VGND_uq2.n55 VGND_uq2.n50 394
R872 VGND_uq2.n84 VGND_uq2.n54 394
R873 VGND_uq2.n161 VGND_uq2.n12 391.45
R874 VGND_uq2.n52 VGND_uq2.n13 390.378
R875 VGND_uq2.n101 VGND_uq2.n42 315
R876 VGND_uq2.n156 VGND_uq2.n15 223.864
R877 VGND_uq2 VGND_uq2 36.4394
R878 VGND_uq2 VGND_uq2 0.909331
R879 VGND_uq2 VGND_uq2 0.909331
R880 VGND_uq2.n120 VGND_uq2 30.6152
R881 VGND_uq2 VGND_uq2 15.7828
R882 VGND_uq2 VGND_uq2 13.6564
R883 VGND_uq2 VGND_uq2 13.6226
R884 VGND_uq2 VGND_uq2 13.4169
R885 VGND_uq2 VGND_uq2 13.383
R886 VGND_uq2 VGND_uq2 12.9377
R887 VGND_uq2 VGND_uq2 12.9038
R888 VGND_uq2.n121 VGND_uq2.n120 12.8005
R889 VGND_uq2.n8 VGND_uq2 11.7346
R890 VGND_uq2.n7 VGND_uq2 11.7346
R891 VGND_uq2.n78 VGND_uq2 9.343
R892 VGND_uq2 VGND_uq2.n131 9.33435
R893 VGND_uq2.n29 VGND_uq2 7.19493
R894 VGND_uq2.n28 VGND_uq2 9.3005
R895 VGND_uq2 VGND_uq2.n10 7.15378
R896 VGND_uq2.n120 VGND_uq2 9.3005
R897 VGND_uq2.n121 VGND_uq2 9.3005
R898 VGND_uq2.n160 VGND_uq2 9.3005
R899 VGND VGND_uq2 7.93251
R900 VGND_uq2.n162 VGND_uq2.n3 7.56446
R901 VGND_uq2.n88 VGND_uq2.n87 7.56446
R902 VGND_uq2.n92 VGND_uq2.n49 7.56446
R903 VGND_uq2.n83 VGND_uq2.n4 7.5578
R904 VGND_uq2.n158 VGND_uq2.n3 7.56446
R905 VGND_uq2 VGND 7.46454
R906 VGND_uq2.n88 VGND_uq2 5.7847
R907 VGND_uq2.n158 VGND_uq2.n14 4.22742
R908 VGND_uq2.n83 VGND_uq2.n56 4.22742
R909 VGND_uq2 VGND_uq2.n1 4.11618
R910 VGND_uq2.n87 VGND_uq2.n14 3.33754
R911 VGND_uq2.n95 VGND_uq2 2.44766
R912 VGND_uq2.n0 VGND_uq2.n5 2.17498
R913 VGND_uq2 VGND_uq2 1.8452
R914 VGND_uq2 VGND_uq2 1.8452
R915 VGND_uq2.n8 VGND_uq2.n6 1.86508
R916 VGND_uq2 VGND_uq2 1.50693
R917 VGND_uq2 VGND_uq2 1.5458
R918 VGND_uq2 VGND_uq2 1.26378
R919 VGND_uq2 VGND_uq2 1.26376
R920 VGND_uq2.n6 VGND_uq2.n5 1.2505
R921 VGND_uq2 VGND_uq2 1.19882
R922 VGND_uq2 VGND_uq2 1.13918
R923 VGND_uq2 VGND_uq2 0.996071
R924 VGND_uq2 VGND_uq2 0.99305
R925 VGND_uq2 VGND_uq2 0.937281
R926 VGND_uq2 VGND_uq2 0.825434
R927 VGND_uq2 VGND_uq2 0.825434
R928 VGND_uq2 VGND_uq2 0.825202
R929 VGND_uq2 VGND_uq2 0.705956
R930 VGND_uq2 VGND_uq2 0.590191
R931 VGND_uq2 VGND_uq2 0.475069
R932 VGND_uq2 VGND_uq2 0.475425
R933 VGND_uq2 VGND_uq2 0.473716
R934 VGND_uq2 VGND_uq2 0.474346
R935 VGND_uq2 VGND_uq2 0.359875
R936 VGND_uq2 VGND_uq2 0.359875
R937 VGND_uq2 VGND_uq2 0.356695
R938 VGND_uq2 VGND_uq2 0.358767
R939 VGND_uq2 VGND_uq2 0.263521
R940 VGND_uq2 VGND_uq2 0.260844
R941 VGND_uq2 VGND_uq2 0.240083
R942 VGND_uq2 VGND_uq2 0.239084
R943 VGND_uq2 VGND_uq2 0.238651
R944 VGND_uq2 VGND_uq2 0.240083
R945 VGND_uq2 VGND_uq2 0.206229
R946 VGND_uq2 VGND_uq2 0.120292
R947 VGND_uq2.n10 VGND_uq2 27.6382
R948 VGND_uq2 VGND_uq2 8362.5
R949 VGND_uq2.n132 VGND_uq2 1205.42
R950 VGND_uq2.n142 VGND_uq2.n24 11.1338
R951 VGND_uq2.n142 VGND_uq2.n6 3811.87
R952 VGND_uq2.n24 VGND_uq2.n6 1501.43
R953 VGND_uq2.n138 VGND_uq2.n6 1337.14
R954 VGND_uq2 VGND_uq2.n30 1205.72
R955 VGND_uq2 VGND_uq2.n29 474.048
R956 VGND_uq2.n9 VGND_uq2 30.8227
R957 VGND_uq2 VGND_uq2 0.700275
R958 VGND_uq2 VGND_uq2.n9 80.8295
R959 VGND_uq2 VGND_uq2.n9 7.77956
R960 VGND_uq2.n164 VGND_uq2.n2 684.759
R961 VGND_uq2.n162 VGND_uq2.n155 7.58756
R962 VGND_uq2.n162 VGND_uq2.n15 950.035
R963 VGND_uq2.n155 VGND_uq2.n15 1534.67
R964 VGND_uq2.n159 VGND_uq2.n13 620.966
R965 VGND_uq2.n153 VGND_uq2.n16 349.709
R966 VGND_uq2.n152 VGND_uq2.n17 404.961
R967 VGND_uq2.n150 VGND_uq2.n18 337.813
R968 VGND_uq2.n148 VGND_uq2.n20 310.428
R969 VGND_uq2.n146 VGND_uq2.n19 403.577
R970 VGND_uq2.n145 VGND_uq2.n22 403.341
R971 VGND_uq2.n143 VGND_uq2.n23 387.533
R972 VGND_uq2.n141 VGND_uq2.n139 77.4325
R973 VGND_uq2.n137 VGND_uq2.n26 300.908
R974 VGND_uq2.n136 VGND_uq2.n26 272.204
R975 VGND_uq2.n133 VGND_uq2.n27 291.274
R976 VGND_uq2.n132 VGND_uq2.n27 400.651
R977 VGND_uq2 VGND_uq2.n28 1951.57
R978 VGND_uq2 VGND_uq2 9136.78
R979 VGND_uq2 VGND_uq2 7945.89
R980 VGND_uq2 VGND_uq2.n29 1988.65
R981 VGND_uq2 VGND_uq2.n29 15060.7
R982 VGND_uq2 VGND_uq2 4371.87
R983 VGND_uq2.n28 VGND_uq2 32.6284
R984 VGND_uq2.n29 VGND_uq2 31.1582
R985 VGND_uq2 VGND_uq2 14482
R986 VGND_uq2.n30 VGND_uq2.n31 419.805
R987 VGND_uq2.n129 VGND_uq2.n32 475.635
R988 VGND_uq2.n127 VGND_uq2.n33 479.536
R989 VGND_uq2.n125 VGND_uq2.n34 460.11
R990 VGND_uq2.n123 VGND_uq2.n35 364.233
R991 VGND_uq2.n122 VGND_uq2.n63 553.028
R992 VGND_uq2 VGND_uq2.n42 336.442
R993 VGND_uq2 VGND_uq2.n121 3348.23
R994 VGND_uq2.n42 VGND_uq2.n121 2053.58
R995 VGND_uq2.n42 VGND_uq2 434.38
R996 VGND_uq2.n42 VGND_uq2.n120 1824.34
R997 VGND_uq2 VGND_uq2.n120 4322.88
R998 VGND_uq2.n108 VGND_uq2.n37 465.897
R999 VGND_uq2.n106 VGND_uq2.n38 479.517
R1000 VGND_uq2.n104 VGND_uq2.n39 464.656
R1001 VGND_uq2 VGND_uq2.n40 655.761
R1002 VGND_uq2.n102 VGND_uq2.n41 478.557
R1003 VGND_uq2.n98 VGND_uq2.n47 365.688
R1004 VGND_uq2.n93 VGND_uq2.n53 491.043
R1005 VGND_uq2.n79 VGND_uq2.n85 35.1124
R1006 VGND_uq2.n79 VGND_uq2 79.213
R1007 VGND_uq2.n85 VGND_uq2 15.2871
R1008 VGND_uq2.n82 VGND_uq2 25.4527
R1009 VGND_uq2.n57 VGND_uq2.n58 645.398
R1010 VGND_uq2.n74 VGND_uq2.n75 317.366
R1011 VGND_uq2.n70 VGND_uq2.n72 108.588
R1012 VGND_uq2.n71 VGND_uq2.n60 470.099
R1013 VGND_uq2.n68 VGND_uq2.n61 464.969
R1014 VGND_uq2.n66 VGND_uq2.n62 502.175
R1015 VGND_uq2.n63 VGND_uq2.n65 549.13
R1016 VGND_uq2.n67 VGND_uq2.n62 365.337
R1017 VGND_uq2.n69 VGND_uq2.n61 352.062
R1018 VGND_uq2.n70 VGND_uq2.n60 378.49
R1019 VGND_uq2.n72 VGND_uq2.n43 422.164
R1020 VGND_uq2.n73 VGND_uq2.n44 478.557
R1021 VGND_uq2.n73 VGND_uq2.n48 420.188
R1022 VGND_uq2.n56 VGND_uq2.n75 212.906
R1023 VGND_uq2.n76 VGND_uq2.n58 305.067
R1024 VGND_uq2.n77 VGND_uq2.n57 13.4566
R1025 VGND_uq2.n78 VGND_uq2.n79 41.7113
R1026 VGND_uq2.n78 VGND_uq2.n80 573.37
R1027 VGND_uq2.n79 VGND_uq2.n80 874.663
R1028 VGND_uq2.n85 VGND_uq2.n54 684.759
R1029 VGND_uq2.n90 VGND_uq2.n86 684.759
R1030 VGND_uq2.n91 VGND_uq2.n90 39.7242
R1031 VGND_uq2.n91 VGND_uq2 51.8839
R1032 VGND_uq2.n90 VGND_uq2 20.1185
R1033 VGND_uq2.n91 VGND_uq2.n55 684.759
R1034 VGND_uq2.n93 VGND_uq2.n94 52.3208
R1035 VGND_uq2.n93 VGND_uq2.n51 742.322
R1036 VGND_uq2.n94 VGND_uq2.n51 742.322
R1037 VGND_uq2.n96 VGND_uq2.n49 303.783
R1038 VGND_uq2.n96 VGND_uq2.n95 303.783
R1039 VGND_uq2.n49 VGND_uq2.n95 7.65982
R1040 VGND_uq2.n98 VGND_uq2.n46 480.37
R1041 VGND_uq2.n102 VGND_uq2.n40 459.647
R1042 VGND_uq2.n103 VGND_uq2.n39 344.082
R1043 VGND_uq2.n105 VGND_uq2.n38 362.485
R1044 VGND_uq2.n107 VGND_uq2.n37 325.113
R1045 VGND_uq2 VGND_uq2.n36 461.942
R1046 VGND_uq2.n117 VGND_uq2.n109 476.808
R1047 VGND_uq2.n115 VGND_uq2.n110 479.536
R1048 VGND_uq2.n113 VGND_uq2.n111 461.19
R1049 VGND_uq2.n112 VGND_uq2.n111 335.827
R1050 VGND_uq2.n114 VGND_uq2.n110 362.486
R1051 VGND_uq2.n116 VGND_uq2.n109 329.199
R1052 VGND_uq2.n118 VGND_uq2.n36 325.704
R1053 VGND_uq2.n119 VGND_uq2 297.954
R1054 VGND_uq2.n121 VGND_uq2 30.7498
R1055 VGND_uq2 VGND_uq2.n122 6641.82
R1056 VGND_uq2.n122 VGND_uq2 1470.31
R1057 VGND_uq2 VGND_uq2.n122 206.852
R1058 VGND_uq2 VGND_uq2.n35 918.307
R1059 VGND_uq2.n122 VGND_uq2.n35 611.808
R1060 VGND_uq2.n124 VGND_uq2.n34 338.656
R1061 VGND_uq2.n126 VGND_uq2.n33 362.486
R1062 VGND_uq2.n128 VGND_uq2.n32 329.122
R1063 VGND_uq2.n130 VGND_uq2.n31 286.175
R1064 VGND_uq2 VGND_uq2 9513.49
R1065 VGND_uq2 VGND_uq2 2971.2
R1066 VGND_uq2 VGND_uq2 9744.02
R1067 VGND_uq2 VGND_uq2 3888.42
R1068 VGND_uq2 VGND_uq2 10247.1
R1069 VGND_uq2 VGND_uq2 8871.24
R1070 VGND_uq2 VGND_uq2.n9 11569.7
R1071 VGND_uq2 VGND_uq2.n9 2361.61
R1072 VGND_uq2 VGND_uq2 4900.03
R1073 VGND_uq2 VGND_uq2.n10 6332.43
R1074 VGND_uq2 VGND_uq2.n10 2621.5
R1075 VGND_uq2 VGND_uq2 2196.74
R1076 VGND_uq2 VGND_uq2.n131 4209.6
R1077 VGND_uq2 VGND_uq2.n131 2549.15
R1078 VGND_uq2.n131 VGND_uq2 31.1745
R1079 VGND_uq2.n135 VGND_uq2.n134 268.577
R1080 VGND_uq2.n139 VGND_uq2.n25 364.781
R1081 VGND_uq2.n24 VGND_uq2.n140 390.942
R1082 VGND_uq2.n142 VGND_uq2.n23 414.337
R1083 VGND_uq2.n144 VGND_uq2.n5 1215.93
R1084 VGND_uq2.n146 VGND_uq2.n145 76.3396
R1085 VGND_uq2.n149 VGND_uq2.n18 341.265
R1086 VGND_uq2.n151 VGND_uq2.n17 378.634
R1087 VGND_uq2.n153 VGND_uq2.n152 76.3366
R1088 VGND_uq2.n155 VGND_uq2.n1 13.5125
R1089 VGND_uq2.n155 VGND_uq2.n156 1130.02
R1090 VGND_uq2.n1 VGND_uq2.n156 1227.44
R1091 VGND_uq2.n157 VGND_uq2.n15 472.813
R1092 VGND_uq2.n159 VGND_uq2.n12 652.72
R1093 VGND_uq2.n164 VGND_uq2.n165 42.3942
R1094 VGND_uq2.n164 VGND_uq2 38.9651
R1095 VGND_uq2.n165 VGND_uq2 25.6601
R1096 VGND_uq2.n28 VGND_uq2 529.374
R1097 VGND_uq2.n29 VGND_uq2 2260.2
R1098 VGND_uq2 VGND_uq2 2473.72
R1099 VGND_uq2.n86 VGND_uq2.n2 1246.43
R1100 VGND_uq2.n86 VGND_uq2.n158 1915.88
R1101 VGND_uq2.n2 VGND_uq2.n158 1915.88
R1102 VGND_uq2.n21 VGND_uq2.n20 336.724
R1103 VGND_uq2 VGND_uq2 3065.71
R1104 VGND_uq2 VGND_uq2 43648.7
R1105 VGND_uq2.n43 VGND_uq2.n44 603.107
R1106 VGND_uq2.n43 VGND_uq2.n100 1585.25
R1107 VGND_uq2.n44 VGND_uq2.n100 1600.95
R1108 VGND_uq2.n65 VGND_uq2.n66 998.716
R1109 VGND_uq2.n63 VGND_uq2.n66 1233.12
R1110 VGND_uq2.n70 VGND_uq2.n71 1575.55
R1111 VGND_uq2.n71 VGND_uq2 987.173
R1112 VGND_uq2.n44 VGND_uq2.n48 630.952
R1113 VGND_uq2.n44 VGND_uq2.n45 1616.47
R1114 VGND_uq2.n48 VGND_uq2.n45 1632.47
R1115 VGND_uq2.n73 VGND_uq2.n45 4182.33
R1116 VGND_uq2.n58 VGND_uq2.n4 745.904
R1117 VGND_uq2.n53 VGND_uq2.n83 1734.15
R1118 VGND_uq2.n54 VGND_uq2.n55 1246.43
R1119 VGND_uq2.n54 VGND_uq2.n92 960.495
R1120 VGND_uq2.n55 VGND_uq2.n92 1915.88
R1121 VGND_uq2.n53 VGND_uq2.n51 1318.72
R1122 VGND_uq2.n53 VGND_uq2.n92 970.967
R1123 VGND_uq2.n51 VGND_uq2.n92 1958
R1124 VGND_uq2.n93 VGND_uq2.n92 2907.18
R1125 VGND_uq2.n13 VGND_uq2.n94 1858.52
R1126 VGND_uq2.n159 VGND_uq2.n94 81.3306
R1127 VGND_uq2.n159 VGND_uq2.n52 1858.52
R1128 VGND_uq2.n94 VGND_uq2.n52 620.966
R1129 VGND_uq2.n51 VGND_uq2.n52 1318.72
R1130 VGND_uq2.n51 VGND_uq2.n95 1958
R1131 VGND_uq2.n52 VGND_uq2.n95 1958
R1132 VGND_uq2.n94 VGND_uq2.n95 2907.18
R1133 VGND_uq2.n46 VGND_uq2.n47 630.952
R1134 VGND_uq2.n46 VGND_uq2.n97 1632.47
R1135 VGND_uq2.n47 VGND_uq2.n97 1616.47
R1136 VGND_uq2.n98 VGND_uq2.n97 4182.33
R1137 VGND_uq2.n41 VGND_uq2.n46 603.107
R1138 VGND_uq2.n41 VGND_uq2.n99 1600.95
R1139 VGND_uq2.n46 VGND_uq2.n99 1585.25
R1140 VGND_uq2.n40 VGND_uq2.n41 630.952
R1141 VGND_uq2.n40 VGND_uq2.n101 1632.47
R1142 VGND_uq2.n41 VGND_uq2.n101 1616.47
R1143 VGND_uq2.n102 VGND_uq2.n101 4182.33
R1144 VGND_uq2 VGND_uq2.n119 1487.07
R1145 VGND_uq2 VGND_uq2.n119 6363.3
R1146 VGND_uq2 VGND_uq2 9669.71
R1147 VGND_uq2 VGND_uq2 9125.54
R1148 VGND_uq2 VGND_uq2 2020.13
R1149 VGND_uq2 VGND_uq2 11364.8
R1150 VGND_uq2 VGND_uq2 2260.51
R1151 VGND_uq2 VGND_uq2 37420.4
R1152 VGND_uq2 VGND_uq2 7443.12
R1153 VGND_uq2 VGND_uq2.n10 101.859
R1154 VGND_uq2.n131 VGND_uq2.n10 6043
R1155 VGND_uq2 VGND_uq2 14233
R1156 VGND_uq2 VGND_uq2 3761.95
R1157 VGND_uq2 VGND_uq2 26044.6
R1158 VGND_uq2.n25 VGND_uq2.n138 335.704
R1159 VGND_uq2.n22 VGND_uq2.n144 367.365
R1160 VGND_uq2.n19 VGND_uq2.n147 332.938
R1161 VGND_uq2.n146 VGND_uq2.n147 1344.55
R1162 VGND_uq2.n19 VGND_uq2.n5 57901.1
R1163 VGND_uq2.n147 VGND_uq2.n5 1402.47
R1164 VGND_uq2.n151 VGND_uq2.n149 28.0126
R1165 VGND_uq2.n16 VGND_uq2.n154 322.397
R1166 VGND_uq2.n153 VGND_uq2.n154 1033.42
R1167 VGND_uq2.n16 VGND_uq2.n0 61493.5
R1168 VGND_uq2.n154 VGND_uq2.n0 1222.34
R1169 VGND_uq2.n13 VGND_uq2.n12 1318.72
R1170 VGND_uq2.n13 VGND_uq2.n158 1958
R1171 VGND_uq2.n12 VGND_uq2.n158 1958
R1172 VGND_uq2.n159 VGND_uq2.n158 2907.18
R1173 VGND_uq2.n12 VGND_uq2.n160 1595.3
R1174 VGND_uq2.n159 VGND_uq2.n160 69.812
R1175 VGND_uq2.n159 VGND_uq2.n161 2645.87
R1176 VGND_uq2.n160 VGND_uq2.n161 506.062
R1177 VGND_uq2.n56 VGND_uq2.n54 849.763
R1178 VGND_uq2.n56 VGND_uq2.n92 10.9878
R1179 VGND_uq2.n56 VGND_uq2.n53 849.763
R1180 VGND_uq2.n54 VGND_uq2.n53 148968
R1181 VGND_uq2.n21 VGND_uq2.n148 903.87
R1182 VGND_uq2.n19 VGND_uq2.n21 945.39
R1183 VGND_uq2.n146 VGND_uq2.n21 169.796
R1184 VGND_uq2.n139 VGND_uq2.n140 1630.44
R1185 VGND_uq2 VGND_uq2 203976
R1186 VGND_uq2 VGND_uq2 8304.88
R1187 VGND_uq2 VGND_uq2 2185.09
R1188 VGND_uq2 VGND_uq2 30305
R1189 VGND_uq2 VGND_uq2 11607.7
R1190 VGND_uq2 VGND_uq2 10794.5
R1191 VGND_uq2.n64 VGND_uq2.n63 2744.08
R1192 VGND_uq2.n66 VGND_uq2.n67 2880.75
R1193 VGND_uq2.n66 VGND_uq2.n64 3166.08
R1194 VGND_uq2.n62 VGND_uq2.n64 1129.23
R1195 VGND_uq2.n67 VGND_uq2.n64 172.018
R1196 VGND_uq2.n67 VGND_uq2.n68 1684.19
R1197 VGND_uq2.n68 VGND_uq2.n62 1384.57
R1198 VGND_uq2.n68 VGND_uq2.n66 2105.36
R1199 VGND_uq2.n68 VGND_uq2.n69 2289.76
R1200 VGND_uq2.n61 VGND_uq2.n67 929.741
R1201 VGND_uq2.n69 VGND_uq2.n67 169.47
R1202 VGND_uq2.n60 VGND_uq2.n69 791.26
R1203 VGND_uq2.n70 VGND_uq2.n69 168.714
R1204 VGND_uq2 VGND_uq2.n43 1980.89
R1205 VGND_uq2 VGND_uq2.n72 4074
R1206 VGND_uq2.n71 VGND_uq2.n43 2658.45
R1207 VGND_uq2.n71 VGND_uq2.n72 3849.67
R1208 VGND_uq2.n100 VGND_uq2.n73 9396.33
R1209 VGND_uq2.n100 VGND_uq2.n72 9396.33
R1210 VGND_uq2.n44 VGND_uq2.n72 1564.36
R1211 VGND_uq2.n73 VGND_uq2.n43 1549.02
R1212 VGND_uq2.n73 VGND_uq2.n72 177.306
R1213 VGND_uq2.n74 VGND_uq2.n56 248.971
R1214 VGND_uq2.n57 VGND_uq2.n76 4384.74
R1215 VGND_uq2.n77 VGND_uq2.n58 1059.65
R1216 VGND_uq2.n77 VGND_uq2.n76 307.711
R1217 VGND_uq2.n77 VGND_uq2.n78 261.036
R1218 VGND_uq2.n83 VGND_uq2.n82 3862.71
R1219 VGND_uq2.n83 VGND_uq2.n93 4953.83
R1220 VGND_uq2.n82 VGND_uq2.n53 1287
R1221 VGND_uq2.n82 VGND_uq2.n93 111.46
R1222 VGND_uq2.n158 VGND_uq2.n90 6276.49
R1223 VGND_uq2.n158 VGND_uq2.n164 6276.49
R1224 VGND_uq2.n86 VGND_uq2.n164 1602.64
R1225 VGND_uq2.n90 VGND_uq2.n2 1602.64
R1226 VGND_uq2.n90 VGND_uq2.n164 112.957
R1227 VGND_uq2.n92 VGND_uq2.n91 6276.49
R1228 VGND_uq2.n92 VGND_uq2.n85 6276.49
R1229 VGND_uq2.n55 VGND_uq2.n85 1602.64
R1230 VGND_uq2.n91 VGND_uq2.n54 1602.64
R1231 VGND_uq2.n91 VGND_uq2.n85 112.957
R1232 VGND_uq2.n99 VGND_uq2.n98 9396.33
R1233 VGND_uq2.n99 VGND_uq2.n102 9396.33
R1234 VGND_uq2.n46 VGND_uq2.n102 1549.02
R1235 VGND_uq2.n98 VGND_uq2.n41 1564.36
R1236 VGND_uq2.n98 VGND_uq2.n102 177.306
R1237 VGND_uq2.n40 VGND_uq2.n103 956.298
R1238 VGND_uq2.n102 VGND_uq2.n103 206.577
R1239 VGND_uq2.n103 VGND_uq2.n104 2210.36
R1240 VGND_uq2.n104 VGND_uq2.n105 1684.19
R1241 VGND_uq2.n39 VGND_uq2.n105 929.741
R1242 VGND_uq2.n103 VGND_uq2.n105 169.47
R1243 VGND_uq2.n105 VGND_uq2.n106 2610.67
R1244 VGND_uq2.n104 VGND_uq2.n38 1384.57
R1245 VGND_uq2.n104 VGND_uq2.n106 2105.36
R1246 VGND_uq2.n106 VGND_uq2.n107 1683.66
R1247 VGND_uq2.n38 VGND_uq2.n107 929.718
R1248 VGND_uq2.n105 VGND_uq2.n107 169.47
R1249 VGND_uq2.n107 VGND_uq2.n108 1667.68
R1250 VGND_uq2.n106 VGND_uq2.n37 1381.92
R1251 VGND_uq2.n106 VGND_uq2.n108 2115.49
R1252 VGND_uq2.n108 VGND_uq2.n119 1468.59
R1253 VGND_uq2.n113 VGND_uq2.n112 2064.05
R1254 VGND_uq2.n113 VGND_uq2.n114 1684.19
R1255 VGND_uq2.n111 VGND_uq2.n114 929.741
R1256 VGND_uq2.n112 VGND_uq2.n114 169.47
R1257 VGND_uq2.n114 VGND_uq2.n115 2610.89
R1258 VGND_uq2.n113 VGND_uq2.n110 1384.57
R1259 VGND_uq2.n113 VGND_uq2.n115 2105.36
R1260 VGND_uq2.n115 VGND_uq2.n116 1684.19
R1261 VGND_uq2.n110 VGND_uq2.n116 929.741
R1262 VGND_uq2.n114 VGND_uq2.n116 169.47
R1263 VGND_uq2.n116 VGND_uq2.n117 1907.73
R1264 VGND_uq2.n115 VGND_uq2.n109 1384.57
R1265 VGND_uq2.n115 VGND_uq2.n117 2105.36
R1266 VGND_uq2.n117 VGND_uq2.n36 1883.65
R1267 VGND_uq2.n117 VGND_uq2 1143.92
R1268 VGND_uq2 VGND_uq2.n118 4701.37
R1269 VGND_uq2.n119 VGND_uq2.n36 1157.71
R1270 VGND_uq2.n119 VGND_uq2.n118 1176.01
R1271 VGND_uq2 VGND_uq2.n123 1549.48
R1272 VGND_uq2.n123 VGND_uq2.n124 157.981
R1273 VGND_uq2.n124 VGND_uq2.n125 2085.53
R1274 VGND_uq2.n125 VGND_uq2.n126 1684.19
R1275 VGND_uq2.n34 VGND_uq2.n126 929.741
R1276 VGND_uq2.n124 VGND_uq2.n126 169.47
R1277 VGND_uq2.n126 VGND_uq2.n127 2610.89
R1278 VGND_uq2.n125 VGND_uq2.n33 1384.57
R1279 VGND_uq2.n125 VGND_uq2.n127 2105.36
R1280 VGND_uq2.n127 VGND_uq2.n128 1684.19
R1281 VGND_uq2.n33 VGND_uq2.n128 929.741
R1282 VGND_uq2.n126 VGND_uq2.n128 169.47
R1283 VGND_uq2.n128 VGND_uq2.n129 1891.69
R1284 VGND_uq2.n127 VGND_uq2.n32 1384.57
R1285 VGND_uq2.n127 VGND_uq2.n129 2105.36
R1286 VGND_uq2.n129 VGND_uq2.n31 1645
R1287 VGND_uq2.n129 VGND_uq2.n30 1334.77
R1288 VGND_uq2.n30 VGND_uq2.n130 1639.03
R1289 VGND_uq2.n132 VGND_uq2.n133 1511.16
R1290 VGND_uq2.n136 VGND_uq2.n137 417.067
R1291 VGND_uq2.n142 VGND_uq2.n141 5184.31
R1292 VGND_uq2.n142 VGND_uq2.n143 2362.16
R1293 VGND_uq2.n141 VGND_uq2.n23 1137.71
R1294 VGND_uq2.n141 VGND_uq2.n143 171.655
R1295 VGND_uq2.n143 VGND_uq2.n144 1369.12
R1296 VGND_uq2.n23 VGND_uq2.n144 903.516
R1297 VGND_uq2.n142 VGND_uq2.n144 46.1442
R1298 VGND_uq2.n144 VGND_uq2.n145 2039.96
R1299 VGND_uq2.n143 VGND_uq2.n22 962.069
R1300 VGND_uq2.n143 VGND_uq2.n145 169.868
R1301 VGND_uq2.n149 VGND_uq2.n150 1233.57
R1302 VGND_uq2.n151 VGND_uq2.n18 2287.42
R1303 VGND_uq2.n151 VGND_uq2.n150 1778.81
R1304 VGND_uq2.n151 VGND_uq2.n152 2177.34
R1305 VGND_uq2.n150 VGND_uq2.n17 959.775
R1306 VGND_uq2.n150 VGND_uq2.n152 170.386
R1307 VGND_uq2.n152 VGND_uq2.n154 2150.87
R1308 VGND_uq2.n17 VGND_uq2.n154 911.139
R1309 VGND_uq2.n151 VGND_uq2.n154 46.2658
R1310 VGND_uq2.n1 VGND_uq2.n160 261.036
R1311 VGND_uq2.n1 VGND_uq2.n165 1021.88
R1312 VGND_uq2.n1 VGND_uq2.n11 2834.74
R1313 VGND_uq2.n11 VGND_uq2 5809.86
R1314 VGND_uq2 VGND_uq2.n1 148.29
R1315 VGND_uq2 VGND_uq2.n165 188.429
R1316 VGND_uq2.n157 VGND_uq2.n14 413.779
R1317 VGND_uq2.n15 VGND_uq2.n14 1079.44
R1318 VGND_uq2.n151 VGND_uq2.n16 7906.47
R1319 VGND_uq2.n151 VGND_uq2.n153 8831.18
R1320 VGND_uq2.n16 VGND_uq2.n17 3430.56
R1321 VGND_uq2.n16 VGND_uq2.n152 3846.61
R1322 VGND_uq2.n17 VGND_uq2.n153 3831.79
R1323 VGND_uq2.n152 VGND_uq2.n18 8618.65
R1324 VGND_uq2.n152 VGND_uq2.n149 11960.3
R1325 VGND_uq2.n18 VGND_uq2.n17 3281.65
R1326 VGND_uq2.n17 VGND_uq2.n149 4554.02
R1327 VGND_uq2.n150 VGND_uq2.n148 2035.23
R1328 VGND_uq2.n148 VGND_uq2.n18 1294.91
R1329 VGND_uq2.n146 VGND_uq2.n148 7167.23
R1330 VGND_uq2.n146 VGND_uq2.n20 8253.09
R1331 VGND_uq2.n148 VGND_uq2.n19 1323.36
R1332 VGND_uq2.n19 VGND_uq2.n20 2998.58
R1333 VGND_uq2.n145 VGND_uq2.n142 19643.5
R1334 VGND_uq2.n145 VGND_uq2.n23 8478.46
R1335 VGND_uq2.n142 VGND_uq2.n22 7503.45
R1336 VGND_uq2.n22 VGND_uq2.n23 3238.62
R1337 VGND_uq2.n143 VGND_uq2.n140 3684.69
R1338 VGND_uq2.n143 VGND_uq2.n24 9628.83
R1339 VGND_uq2.n142 VGND_uq2.n140 3770.73
R1340 VGND_uq2.n23 VGND_uq2.n140 1407.49
R1341 VGND_uq2.n23 VGND_uq2.n24 3678.04
R1342 VGND_uq2.n141 VGND_uq2.n24 3019.28
R1343 VGND_uq2.n137 VGND_uq2.n25 1417.33
R1344 VGND_uq2.n137 VGND_uq2.n138 1217.6
R1345 VGND_uq2.n30 VGND_uq2.n128 9782.17
R1346 VGND_uq2.n30 VGND_uq2.n32 8402.62
R1347 VGND_uq2.n128 VGND_uq2.n31 1556.81
R1348 VGND_uq2.n31 VGND_uq2.n32 2217.02
R1349 VGND_uq2.n129 VGND_uq2.n126 37960
R1350 VGND_uq2.n129 VGND_uq2.n33 14500.1
R1351 VGND_uq2.n126 VGND_uq2.n32 6836.18
R1352 VGND_uq2.n32 VGND_uq2.n33 2611.3
R1353 VGND_uq2.n127 VGND_uq2.n124 37960
R1354 VGND_uq2.n127 VGND_uq2.n34 14500.1
R1355 VGND_uq2.n124 VGND_uq2.n33 6836.18
R1356 VGND_uq2.n33 VGND_uq2.n34 2611.3
R1357 VGND_uq2.n125 VGND_uq2.n123 8004.69
R1358 VGND_uq2.n123 VGND_uq2.n34 2616.62
R1359 VGND_uq2.n119 VGND_uq2.n107 4651.24
R1360 VGND_uq2.n119 VGND_uq2.n37 5413.5
R1361 VGND_uq2.n108 VGND_uq2.n105 38142.7
R1362 VGND_uq2.n108 VGND_uq2.n38 14569.8
R1363 VGND_uq2.n105 VGND_uq2.n37 6832.59
R1364 VGND_uq2.n37 VGND_uq2.n38 2609.93
R1365 VGND_uq2.n106 VGND_uq2.n103 37960
R1366 VGND_uq2.n106 VGND_uq2.n39 14500.1
R1367 VGND_uq2.n103 VGND_uq2.n38 6836.18
R1368 VGND_uq2.n38 VGND_uq2.n39 2611.3
R1369 VGND_uq2.n104 VGND_uq2.n102 23727.9
R1370 VGND_uq2.n104 VGND_uq2.n40 6466.52
R1371 VGND_uq2.n102 VGND_uq2.n39 6254.11
R1372 VGND_uq2.n39 VGND_uq2.n40 2206.34
R1373 VGND_uq2.n98 VGND_uq2.n14 342.863
R1374 VGND_uq2.n47 VGND_uq2.n14 543.399
R1375 VGND_uq2.n43 VGND_uq2.n60 3822.81
R1376 VGND_uq2.n43 VGND_uq2.n70 3672.81
R1377 VGND_uq2 VGND_uq2.n60 7388.45
R1378 VGND_uq2 VGND_uq2.n70 7098.54
R1379 VGND_uq2.n60 VGND_uq2.n72 4514.74
R1380 VGND_uq2.n70 VGND_uq2.n68 21054.1
R1381 VGND_uq2.n70 VGND_uq2.n61 5603.94
R1382 VGND_uq2.n68 VGND_uq2.n60 4554.81
R1383 VGND_uq2.n60 VGND_uq2.n61 1634.19
R1384 VGND_uq2.n69 VGND_uq2.n66 37960
R1385 VGND_uq2.n69 VGND_uq2.n62 6836.18
R1386 VGND_uq2.n66 VGND_uq2.n61 14500.1
R1387 VGND_uq2.n61 VGND_uq2.n62 2611.3
R1388 VGND_uq2.n67 VGND_uq2.n63 46183
R1389 VGND_uq2.n67 VGND_uq2.n65 3440.39
R1390 VGND_uq2.n62 VGND_uq2.n63 17693.5
R1391 VGND_uq2.n62 VGND_uq2.n65 1318.07
R1392 VGND_uq2.n65 VGND_uq2.n122 8178.49
R1393 VGND_uq2.n65 VGND_uq2.n35 1369.21
R1394 VGND_uq2.n64 VGND_uq2.n122 11244.4
R1395 VGND_uq2.n64 VGND_uq2.n35 1119.31
R1396 VGND_uq2.n63 VGND_uq2.n35 1767.87
R1397 VGND_uq2.n122 VGND_uq2.n123 15090.5
R1398 VGND_uq2.n63 VGND_uq2.n123 6185.13
R1399 VGND_uq2.n65 VGND_uq2.n123 3632.36
R1400 VGND_uq2.n64 VGND_uq2.n123 171.571
R1401 VGND_uq2.n68 VGND_uq2.n71 7081.23
R1402 VGND_uq2.n61 VGND_uq2.n71 4656.89
R1403 VGND_uq2.n69 VGND_uq2.n71 5664.64
R1404 VGND_uq2.n75 VGND_uq2.n73 8496.69
R1405 VGND_uq2.n75 VGND_uq2.n48 7239.62
R1406 VGND_uq2.n56 VGND_uq2.n73 2700.49
R1407 VGND_uq2.n56 VGND_uq2.n48 1838.34
R1408 VGND_uq2.n74 VGND_uq2.n73 227.392
R1409 VGND_uq2.n74 VGND_uq2.n48 1175.83
R1410 VGND_uq2.n75 VGND_uq2.n4 388835
R1411 VGND_uq2.n75 VGND_uq2.n58 103473
R1412 VGND_uq2.n74 VGND_uq2.n4 81817.6
R1413 VGND_uq2.n74 VGND_uq2.n58 21771.5
R1414 VGND_uq2.n58 VGND_uq2.n56 1111.78
R1415 VGND_uq2.n75 VGND_uq2.n76 21861.3
R1416 VGND_uq2.n74 VGND_uq2.n76 4599.23
R1417 VGND_uq2.n56 VGND_uq2.n76 436.832
R1418 VGND_uq2.n4 VGND_uq2.n76 3615.67
R1419 VGND_uq2.n104 VGND_uq2 5100.65
R1420 VGND_uq2.n39 VGND_uq2 3239.94
R1421 VGND_uq2.n103 VGND_uq2 3480.84
R1422 VGND_uq2.n102 VGND_uq2 11168
R1423 VGND_uq2.n107 VGND_uq2.n118 279.863
R1424 VGND_uq2.n37 VGND_uq2.n118 1307.09
R1425 VGND_uq2.n108 VGND_uq2.n118 1712.81
R1426 VGND_uq2 VGND_uq2.n116 8383.51
R1427 VGND_uq2 VGND_uq2.n109 7201.21
R1428 VGND_uq2.n116 VGND_uq2.n36 1582.7
R1429 VGND_uq2.n36 VGND_uq2.n109 2278.83
R1430 VGND_uq2.n117 VGND_uq2.n114 37960
R1431 VGND_uq2.n117 VGND_uq2.n110 14500.1
R1432 VGND_uq2.n114 VGND_uq2.n109 6836.18
R1433 VGND_uq2.n109 VGND_uq2.n110 2611.3
R1434 VGND_uq2.n115 VGND_uq2.n112 37960
R1435 VGND_uq2.n115 VGND_uq2.n111 14500.1
R1436 VGND_uq2.n112 VGND_uq2.n110 6836.18
R1437 VGND_uq2.n110 VGND_uq2.n111 2611.3
R1438 VGND_uq2.n111 VGND_uq2.n27 2889.37
R1439 VGND_uq2.n112 VGND_uq2.n27 930.057
R1440 VGND_uq2.n27 VGND_uq2.n113 7639.11
R1441 VGND_uq2.n116 VGND_uq2.n118 297.495
R1442 VGND_uq2.n109 VGND_uq2.n118 1638.66
R1443 VGND_uq2.n117 VGND_uq2.n118 3123.08
R1444 VGND_uq2.n128 VGND_uq2.n130 297.425
R1445 VGND_uq2.n32 VGND_uq2.n130 1636.2
R1446 VGND_uq2.n129 VGND_uq2.n130 3067.66
R1447 VGND_uq2.n133 VGND_uq2 1744.83
R1448 VGND_uq2.n27 VGND_uq2 13703.3
R1449 VGND_uq2.n132 VGND_uq2 32433.5
R1450 VGND_uq2.n135 VGND_uq2.n8 286.07
R1451 VGND_uq2.n134 VGND_uq2.n8 895.606
R1452 VGND_uq2.n135 VGND_uq2 858.249
R1453 VGND_uq2.n134 VGND_uq2 941.202
R1454 VGND_uq2.n137 VGND_uq2.n139 284.125
R1455 VGND_uq2.n138 VGND_uq2.n139 1214.47
R1456 VGND_uq2.n140 VGND_uq2.n25 1422.4
R1457 VGND_uq2.n141 VGND_uq2.n25 7791.64
R1458 VGND_uq2.n25 VGND_uq2.n24 1357.58
R1459 VGND_uq2.n139 VGND_uq2.n24 3926.62
R1460 VGND_uq2.n145 VGND_uq2.n147 2159.82
R1461 VGND_uq2.n22 VGND_uq2.n147 907.949
R1462 VGND_uq2.n144 VGND_uq2.n147 46.1956
R1463 VGND_uq2.n148 VGND_uq2.n149 55.9888
R1464 VGND_uq2.n157 VGND_uq2.n3 3612.33
R1465 VGND_uq2.n15 VGND_uq2.n3 1215.97
R1466 VGND_uq2.n75 VGND_uq2.n96 19840.9
R1467 VGND_uq2.n56 VGND_uq2.n96 4978.85
R1468 VGND_uq2.n74 VGND_uq2.n96 4605.49
R1469 VGND_uq2.n73 VGND_uq2.n96 5098.07
R1470 VGND_uq2.n48 VGND_uq2.n96 1320.67
R1471 VGND_uq2.n77 VGND_uq2.n80 4981.96
R1472 VGND_uq2.n78 VGND_uq2.n57 2136.58
R1473 VGND_uq2.n80 VGND_uq2.n57 666.588
R1474 VGND_uq2.n59 VGND_uq2.n7 99.7517
R1475 VGND_uq2.n113 VGND_uq2.n132 7186.21
R1476 VGND_uq2.n112 VGND_uq2.n132 3169.33
R1477 VGND_uq2.n111 VGND_uq2.n132 4141.57
R1478 VGND_uq2.n113 VGND_uq2.n133 15159.9
R1479 VGND_uq2.n111 VGND_uq2.n133 4630.4
R1480 VGND_uq2.n112 VGND_uq2.n133 219.325
R1481 VGND_uq2.n80 VGND_uq2.n81 91880.8
R1482 VGND_uq2.n77 VGND_uq2.n81 4635.24
R1483 VGND_uq2.n81 VGND_uq2.n57 665.774
R1484 VGND_uq2.n57 VGND_uq2.n4 15.4081
R1485 VGND_uq2.n80 VGND_uq2.n4 739.388
R1486 VGND_uq2.n4 VGND_uq2.n81 710.009
R1487 VGND_uq2.n93 VGND_uq2.n81 4834.35
R1488 VGND_uq2.n93 VGND_uq2.n4 7177.9
R1489 VGND_uq2.n83 VGND_uq2.n81 5779.21
R1490 VGND_uq2.n53 VGND_uq2.n81 3759.85
R1491 VGND_uq2.n53 VGND_uq2.n4 5582.52
R1492 VGND_uq2.n82 VGND_uq2.n4 3066.89
R1493 VGND_uq2.n80 VGND_uq2.n84 1318.72
R1494 VGND_uq2.n84 VGND_uq2.n79 1958
R1495 VGND_uq2.n84 VGND_uq2.n4 1958
R1496 VGND_uq2.n79 VGND_uq2.n4 2907.18
R1497 VGND_uq2.n157 VGND_uq2.n153 359.868
R1498 VGND_uq2.n157 VGND_uq2.n16 1748.19
R1499 VGND_uq2.n157 VGND_uq2.n0 176026
R1500 VGND_uq2.n157 VGND_uq2.n154 2709.84
R1501 VGND_uq2.n153 VGND_uq2.n0 211170
R1502 VGND_uq2.n149 VGND_uq2.n21 3675.37
R1503 VGND_uq2.n149 VGND_uq2.n20 3847.46
R1504 VGND_uq2.n18 VGND_uq2.n21 1922.87
R1505 VGND_uq2.n18 VGND_uq2.n20 4412.79
R1506 VGND_uq2.n150 VGND_uq2.n21 373.618
R1507 VGND_uq2.n150 VGND_uq2.n20 1940.09
R1508 VGND_uq2.n144 VGND_uq2.n19 7911.43
R1509 VGND_uq2.n144 VGND_uq2.n146 8836.73
R1510 VGND_uq2.n19 VGND_uq2.n22 3411.28
R1511 VGND_uq2.n19 VGND_uq2.n145 3855.11
R1512 VGND_uq2.n22 VGND_uq2.n146 3810.25
R1513 VGND_uq2.n148 VGND_uq2.n5 8062.14
R1514 VGND_uq2.n148 VGND_uq2.n147 69.2007
R1515 VGND_uq2.n20 VGND_uq2.n5 193256
R1516 VGND_uq2.n20 VGND_uq2.n147 1658.79
R1517 VGND_uq2.n21 VGND_uq2.n5 266855
R1518 VGND_uq2.n21 VGND_uq2.n147 2290.51
R1519 VGND_uq2.n24 VGND_uq2.n138 59.7297
R1520 VGND_uq2.n141 VGND_uq2.n138 12912.2
R1521 VGND_uq2.n140 VGND_uq2.n138 1362.16
R1522 VGND_uq2.n6 VGND_uq2.n25 111151
R1523 VGND_uq2.n139 VGND_uq2.n26 8864.17
R1524 VGND_uq2.n139 VGND_uq2.n136 3782.44
R1525 VGND_uq2.n138 VGND_uq2.n26 3488.68
R1526 VGND_uq2.n138 VGND_uq2.n136 48.9544
R1527 VGND_uq2.n25 VGND_uq2.n26 13379.6
R1528 VGND_uq2.n25 VGND_uq2.n136 4263.97
R1529 VGND_uq2.n34 VGND_uq2.n35 6451.86
R1530 VGND_uq2.n34 VGND_uq2 3641.13
R1531 VGND_uq2.n125 VGND_uq2.n35 16462
R1532 VGND_uq2.n125 VGND_uq2 6758.17
R1533 VGND_uq2.n124 VGND_uq2.n35 3347.38
R1534 VGND_uq2.n124 VGND_uq2 2765.64
R1535 VGND_uq2.n37 VGND_uq2.n36 10294.2
R1536 VGND_uq2.n37 VGND_uq2 206794
R1537 VGND_uq2.n107 VGND_uq2.n36 7342.67
R1538 VGND_uq2.n107 VGND_uq2 147502
R1539 VGND_uq2.n36 VGND_uq2.n108 6450.97
R1540 VGND_uq2 VGND_uq2.n108 129589
R1541 VGND_uq2.n3 VGND_uq2.n98 165627
R1542 VGND_uq2.n47 VGND_uq2.n157 44509.9
R1543 VGND_uq2.n98 VGND_uq2.n15 44073.2
R1544 VGND_uq2.n98 VGND_uq2.n157 9310.56
R1545 VGND_uq2.n154 VGND_uq2 71.2788
R1546 VGND_uq2.n16 VGND_uq2 1104.05
R1547 VGND_uq2.n153 VGND_uq2 1689.26
R1548 VGND_uq2.n157 VGND_uq2 966.942
R1549 VGND_uq2 VGND_uq2.n0 1192.18
R1550 VGND_uq2.n154 VGND_uq2.n156 6657.23
R1551 VGND_uq2.n16 VGND_uq2.n156 9674.6
R1552 VGND_uq2.n153 VGND_uq2.n156 4397.72
R1553 VGND_uq2.n156 VGND_uq2 855.1
R1554 VGND_uq2.n135 VGND_uq2.n133 926.189
R1555 VGND_uq2.n134 VGND_uq2.n133 5543.4
R1556 VGND_uq2.n8 VGND_uq2.n137 1801.6
R1557 VGND_uq2.n8 VGND_uq2.n26 4255.6
R1558 VGND_uq2.n134 VGND_uq2.n136 713.538
R1559 VGND_uq2.n134 VGND_uq2.n137 5748.92
R1560 VGND_uq2.n134 VGND_uq2.n26 9804.53
R1561 VGND_uq2.n135 VGND_uq2.n136 2172.79
R1562 VGND_uq2.n135 VGND_uq2.n137 15248.8
R1563 VGND_uq2.n135 VGND_uq2.n26 28362.8
R1564 VGND_uq2.n134 VGND_uq2.n27 68399.8
R1565 VGND_uq2.n134 VGND_uq2.n132 180073
R1566 VGND_uq2.n135 VGND_uq2.n27 11519.4
R1567 VGND_uq2.n135 VGND_uq2.n132 30361.2
R1568 VGND_uq2.n136 VGND_uq2 233.185
R1569 VGND_uq2.n137 VGND_uq2 1903.87
R1570 VGND_uq2.n26 VGND_uq2 3219.23
R1571 VGND_uq2.n8 VGND_uq2 758.035
R1572 VGND_uq2 VGND_uq2 2753.98
R1573 VGND_uq2 VGND_uq2 15071.6
R1574 VGND_uq2 VGND_uq2 15841.7
R1575 VGND_uq2 VGND_uq2 86696.4
R1576 VGND_uq2.n1 VGND_uq2.n161 4981.96
R1577 VGND_uq2.n160 VGND_uq2.n155 2136.58
R1578 VGND_uq2.n161 VGND_uq2.n155 1512.88
R1579 VGND_uq2 VGND_uq2 20535.1
R1580 VGND_uq2 VGND_uq2 112147
R1581 VGND_uq2 VGND_uq2 2330
R1582 VGND_uq2 VGND_uq2 8244.14
R1583 VGND_uq2 VGND_uq2 1938.22
R1584 VGND_uq2 VGND_uq2 129864
R1585 VGND_uq2 VGND_uq2 30531.4
R1586 VGND_uq2.n28 VGND_uq2 7234.65
R1587 VGND_uq2 VGND_uq2 2597.7
R1588 VGND_uq2.n81 VGND_uq2 2372.84
R1589 VGND_uq2.n57 VGND_uq2 3523.12
R1590 VGND_uq2.n57 VGND_uq2.n82 5847.36
R1591 VGND_uq2.n77 VGND_uq2 430.437
R1592 VGND_uq2.n77 VGND_uq2.n82 714.399
R1593 VGND_uq2 VGND_uq2 57525.5
R1594 VGND_uq2 VGND_uq2 17398.4
R1595 VGND_uq2 VGND_uq2 6648.23
R1596 VGND_uq2 VGND_uq2 2010.73
R1597 VGND_uq2.n7 VGND_uq2 2920.08
R1598 VGND_uq2.n59 VGND_uq2 3041.06
R1599 VGND_uq2.n31 VGND_uq2 14516.6
R1600 VGND_uq2.n130 VGND_uq2 1417.64
R1601 VGND_uq2.n30 VGND_uq2 23231.5
R1602 VGND_uq2.n59 VGND_uq2.n30 63795.2
R1603 VGND_uq2.n59 VGND_uq2.n31 25880.3
R1604 VGND_uq2.n59 VGND_uq2.n130 2189.2
R1605 VGND_uq2.n7 VGND_uq2.n30 58141.4
R1606 VGND_uq2.n7 VGND_uq2.n31 23415.2
R1607 VGND_uq2.n7 VGND_uq2.n130 1972.56
R1608 VGND_uq2.n30 VGND_uq2 95472.4
R1609 VGND_uq2.n130 VGND_uq2 5970.71
R1610 VGND_uq2.n31 VGND_uq2 59347
R1611 VGND_uq2.n59 VGND_uq2 18547.5
R1612 VGND_uq2.n7 VGND_uq2.n77 363.863
R1613 VGND_uq2.n7 VGND_uq2.n76 2071.72
R1614 VGND_uq2.n59 VGND_uq2.n77 815.061
R1615 VGND_uq2.n59 VGND_uq2.n76 2895.74
R1616 VGND_uq2.n7 VGND_uq2.n58 31994.8
R1617 VGND_uq2.n59 VGND_uq2.n58 48904
R1618 VGND_uq2 VGND_uq0.n156 14778.3
R1619 VGND_uq2 VGND_uq2 864.962
R1620 VGND_uq0.n155 VGND_uq2 2434.77
R1621 VGND_uq0.n156 VGND_uq0.n24 1470.65
R1622 VGND_uq0.n173 VGND_uq2 1197.5
R1623 VGND_uq0.n198 VGND_uq0.n5 1179.3
R1624 VGND_uq0.n188 VGND_uq0.n0 1053.74
R1625 VGND_uq0.n98 VGND_uq0.n6 1085.61
R1626 VGND_uq0.n96 VGND_uq0.n7 1179.3
R1627 VGND_uq0.n24 VGND_uq2 549.09
R1628 VGND_uq2 VGND_uq0.n155 640.614
R1629 VGND_uq0.n200 VGND_uq0.n10 263.635
R1630 VGND_uq0.n132 VGND_uq0.n39 585
R1631 VGND_uq0.n134 VGND_uq0.n133 585
R1632 VGND_uq0.n38 VGND_uq0.n37 585
R1633 VGND_uq0.n137 VGND_uq0.n33 585
R1634 VGND_uq0.n139 VGND_uq0.n138 585
R1635 VGND_uq0.n114 VGND_uq0.n113 384.901
R1636 VGND_uq0.n22 VGND_uq0.n21 585
R1637 VGND_uq0.n176 VGND_uq0.n22 546.876
R1638 VGND_uq0.n179 VGND_uq0.n178 585
R1639 VGND_uq0.n178 VGND_uq0.n177 585
R1640 VGND_uq0.n20 VGND_uq0.n2 585
R1641 VGND_uq0.n127 VGND_uq0.n126 585
R1642 VGND_uq0.n45 VGND_uq0.n44 585
R1643 VGND_uq0.n128 VGND_uq0.n44 585
R1644 VGND_uq0.n131 VGND_uq0.n130 585
R1645 VGND_uq0.n130 VGND_uq0.n129 585
R1646 VGND_uq0.n43 VGND_uq0.n41 585
R1647 VGND_uq0.n48 VGND_uq0.n47 585
R1648 VGND_uq0.n117 VGND_uq0.n116 585
R1649 VGND_uq0.n119 VGND_uq0.n118 585
R1650 VGND_uq0.n131 VGND_uq0.n42 585
R1651 VGND_uq0.n126 VGND_uq0.n46 585
R1652 VGND_uq0.n2 VGND_uq0.n1 585
R1653 VGND_uq0.n180 VGND_uq0.n179 585
R1654 VGND_uq0.n181 VGND_uq0.n180 509.341
R1655 VGND_uq0.n138 VGND_uq0.n35 585
R1656 VGND_uq0.n136 VGND_uq0.n36 585
R1657 VGND_uq0.n66 VGND_uq0.n65 585
R1658 VGND_uq0.n137 VGND_uq0.n136 510
R1659 VGND_uq0.n136 VGND_uq0.n37 505
R1660 VGND_uq0.n138 VGND_uq0.n137 505
R1661 VGND_uq0.n180 VGND_uq0.n1 394
R1662 VGND_uq0.n178 VGND_uq0.n22 394
R1663 VGND_uq0.n178 VGND_uq0.n20 394
R1664 VGND_uq0.n127 VGND_uq0.n44 394
R1665 VGND_uq0.n130 VGND_uq0.n44 394
R1666 VGND_uq0.n130 VGND_uq0.n43 394
R1667 VGND_uq0.n116 VGND_uq0.n48 394
R1668 VGND_uq0.n138 VGND_uq0.n34 315
R1669 VGND_uq0.n133 VGND_uq0.n38 228.341
R1670 VGND_uq0.n133 VGND_uq0.n39 226.102
R1671 VGND_uq0.n139 VGND_uq0.n33 224.355
R1672 VGND_uq0.n122 VGND_uq0.n19 222.186
R1673 VGND_uq0.n66 VGND_uq0.n53 222.186
R1674 VGND_uq0.n113 VGND_uq0.n77 223.864
R1675 VGND_uq0.n65 VGND_uq2 157.049
R1676 VGND_uq2 VGND_uq2 36.4394
R1677 VGND_uq2 VGND_uq2 0.909331
R1678 VGND_uq2 VGND_uq2 0.909331
R1679 VGND_uq0.n166 VGND_uq2 30.6152
R1680 VGND_uq2 VGND_uq2 15.7806
R1681 VGND_uq2 VGND_uq2 13.6564
R1682 VGND_uq2 VGND_uq2 13.6226
R1683 VGND_uq2 VGND_uq2 13.4169
R1684 VGND_uq2 VGND_uq2 13.383
R1685 VGND_uq2 VGND_uq2 12.9377
R1686 VGND_uq2 VGND_uq2 12.9038
R1687 VGND_uq0.n167 VGND_uq0.n166 12.8005
R1688 VGND_uq2 VGND_uq0.n4 11.7346
R1689 VGND_uq2 VGND_uq0.n8 11.7346
R1690 VGND_uq0.n110 VGND_uq2 9.343
R1691 VGND_uq0.n160 VGND_uq2 9.33435
R1692 VGND_uq0.n166 VGND_uq2 9.3005
R1693 VGND_uq0.n167 VGND_uq2 9.3005
R1694 VGND_uq0.n157 VGND_uq2 7.19493
R1695 VGND_uq0.n158 VGND_uq2 9.3005
R1696 VGND_uq2 VGND_uq0.n9 7.15377
R1697 VGND_uq0.n108 VGND_uq2 9.3005
R1698 VGND_uq2 VGND 7.93251
R1699 VGND_uq0.n179 VGND_uq0.n2 7.56446
R1700 VGND_uq0.n126 VGND_uq0.n45 7.56446
R1701 VGND_uq0.n118 VGND_uq0.n41 7.56446
R1702 VGND_uq0.n118 VGND_uq0.n47 7.56446
R1703 VGND_uq0.n124 VGND_uq0.n2 7.56446
R1704 VGND VGND_uq2 7.46454
R1705 VGND_uq0.n45 VGND_uq2 5.7847
R1706 VGND_uq0.n125 VGND_uq0.n124 4.22742
R1707 VGND_uq2 VGND_uq0.n182 4.11618
R1708 VGND_uq0.n126 VGND_uq0.n125 3.33754
R1709 VGND_uq0.n115 VGND_uq0.n47 3.33754
R1710 VGND_uq0.n131 VGND_uq2 2.44766
R1711 VGND_uq2 VGND_uq2 1.8452
R1712 VGND_uq2 VGND_uq2 1.8452
R1713 VGND_uq0.n5 VGND_uq0.n4 1.86508
R1714 VGND_uq2 VGND_uq2 1.50693
R1715 VGND_uq2 VGND_uq2 1.5458
R1716 VGND_uq2 VGND_uq2 1.26378
R1717 VGND_uq2 VGND_uq2 1.26376
R1718 VGND_uq0.n7 VGND_uq0.n6 1.2505
R1719 VGND_uq2 VGND_uq2 1.19882
R1720 VGND_uq2 VGND_uq2 1.13918
R1721 VGND_uq2 VGND_uq2 0.996221
R1722 VGND_uq2 VGND_uq2 0.99305
R1723 VGND_uq2 VGND_uq2 0.937281
R1724 VGND_uq2 VGND_uq2 0.825434
R1725 VGND_uq2 VGND_uq2 0.825202
R1726 VGND_uq2 VGND_uq2 0.825434
R1727 VGND_uq2 VGND_uq2 0.71925
R1728 VGND_uq2 VGND_uq2 0.590191
R1729 VGND_uq2 VGND_uq2 0.475069
R1730 VGND_uq2 VGND_uq2 0.475425
R1731 VGND_uq2 VGND_uq2 0.473716
R1732 VGND_uq2 VGND_uq2 0.474346
R1733 VGND_uq2 VGND_uq2 0.359875
R1734 VGND_uq2 VGND_uq2 0.359875
R1735 VGND_uq2 VGND_uq2 0.356695
R1736 VGND_uq2 VGND_uq2 0.358767
R1737 VGND_uq2 VGND_uq2 0.263521
R1738 VGND_uq2 VGND_uq2 0.260844
R1739 VGND_uq2 VGND_uq2 0.240083
R1740 VGND_uq2 VGND_uq2 0.239084
R1741 VGND_uq2 VGND_uq2 0.238651
R1742 VGND_uq2 VGND_uq2 0.240083
R1743 VGND_uq2 VGND_uq2 0.206229
R1744 VGND_uq2 VGND_uq2 0.120292
R1745 VGND_uq0.n9 VGND_uq2 27.6382
R1746 VGND_uq2 VGND_uq2 8362.5
R1747 VGND_uq0.n164 VGND_uq2 1205.42
R1748 VGND_uq0.n165 VGND_uq2 30.7348
R1749 VGND_uq0.n185 VGND_uq0.n0 1222.76
R1750 VGND_uq2 VGND_uq0.n168 1205.72
R1751 VGND_uq2 VGND_uq0.n165 7.18293
R1752 VGND_uq2 VGND_uq0.n157 474.048
R1753 VGND_uq0.n159 VGND_uq2 30.8227
R1754 VGND_uq2 VGND_uq2 0.700275
R1755 VGND_uq2 VGND_uq0.n159 80.8295
R1756 VGND_uq2 VGND_uq0.n159 7.77956
R1757 VGND_uq2 VGND_uq0.n155 1216.92
R1758 VGND_uq0.n158 VGND_uq2 32.6284
R1759 VGND_uq0.n157 VGND_uq2 31.1582
R1760 VGND_uq0.n160 VGND_uq2 31.1745
R1761 VGND_uq2 VGND_uq2 3888.42
R1762 VGND_uq2 VGND_uq2 26044.6
R1763 VGND_uq0.n200 VGND_uq0.n4 251.585
R1764 VGND_uq0.n198 VGND_uq0.n11 326.418
R1765 VGND_uq0.n194 VGND_uq0.n13 303.598
R1766 VGND_uq0.n192 VGND_uq0.n14 338.396
R1767 VGND_uq0.n188 VGND_uq0.n16 335.413
R1768 VGND_uq0.n187 VGND_uq0.n17 378.486
R1769 VGND_uq0.n183 VGND_uq0.n19 472.538
R1770 VGND_uq0.n21 VGND_uq0.n182 13.5106
R1771 VGND_uq0.n21 VGND_uq0.n19 1130.02
R1772 VGND_uq0.n182 VGND_uq0.n19 1227.44
R1773 VGND_uq0.n121 VGND_uq0.n181 52.3208
R1774 VGND_uq0.n121 VGND_uq0.n1 742.322
R1775 VGND_uq0.n181 VGND_uq0.n1 1195.6
R1776 VGND_uq0.n179 VGND_uq0.n21 7.58756
R1777 VGND_uq0.n179 VGND_uq0.n122 950.035
R1778 VGND_uq0.n21 VGND_uq0.n122 1534.67
R1779 VGND_uq0.n177 VGND_uq0.n20 684.759
R1780 VGND_uq0.n173 VGND_uq0.n174 375.445
R1781 VGND_uq0.n175 VGND_uq0.n174 388.733
R1782 VGND_uq0.n171 VGND_uq0.n23 427.464
R1783 VGND_uq0.n170 VGND_uq0.n169 296.197
R1784 VGND_uq0.n57 VGND_uq0.n25 296.579
R1785 VGND_uq0.n168 VGND_uq0.n25 406.173
R1786 VGND_uq0.n65 VGND_uq0.n67 269.005
R1787 VGND_uq2 VGND_uq0.n34 336.442
R1788 VGND_uq2 VGND_uq0.n167 3348.23
R1789 VGND_uq0.n34 VGND_uq0.n167 2053.58
R1790 VGND_uq0.n34 VGND_uq2 434.38
R1791 VGND_uq0.n34 VGND_uq0.n166 1824.34
R1792 VGND_uq2 VGND_uq0.n166 4322.88
R1793 VGND_uq0.n164 VGND_uq0.n26 419.462
R1794 VGND_uq0.n154 VGND_uq0.n27 475.635
R1795 VGND_uq0.n152 VGND_uq0.n28 479.536
R1796 VGND_uq0.n150 VGND_uq0.n29 461.063
R1797 VGND_uq0.n148 VGND_uq0.n147 363.07
R1798 VGND_uq0.n146 VGND_uq0.n30 483.808
R1799 VGND_uq0.n144 VGND_uq0.n31 472.945
R1800 VGND_uq0.n142 VGND_uq0.n32 459.399
R1801 VGND_uq0.n140 VGND_uq0.n139 465.207
R1802 VGND_uq0.n134 VGND_uq0.n39 472.666
R1803 VGND_uq0.n129 VGND_uq0.n43 684.759
R1804 VGND_uq0.n120 VGND_uq0.n119 507.332
R1805 VGND_uq0.n111 VGND_uq0.n117 35.1124
R1806 VGND_uq0.n111 VGND_uq2 79.213
R1807 VGND_uq0.n117 VGND_uq2 15.2871
R1808 VGND_uq0.n74 VGND_uq0.n50 477.565
R1809 VGND_uq0.n72 VGND_uq0.n51 479.536
R1810 VGND_uq0.n70 VGND_uq0.n52 461.204
R1811 VGND_uq0.n68 VGND_uq0.n66 459.779
R1812 VGND_uq0.n63 VGND_uq0.n54 376.928
R1813 VGND_uq0.n61 VGND_uq0.n55 362.486
R1814 VGND_uq0.n59 VGND_uq0.n56 338.63
R1815 VGND_uq0.n58 VGND_uq0.n56 467.481
R1816 VGND_uq0.n60 VGND_uq0.n55 479.536
R1817 VGND_uq0.n62 VGND_uq0.n54 466.705
R1818 VGND_uq0.n63 VGND_uq0.n64 76.019
R1819 VGND_uq2 VGND_uq0.n53 606.778
R1820 VGND_uq0.n69 VGND_uq0.n52 340.428
R1821 VGND_uq0.n71 VGND_uq0.n51 362.486
R1822 VGND_uq0.n73 VGND_uq0.n50 343.267
R1823 VGND_uq0.n75 VGND_uq0.n35 404.914
R1824 VGND_uq0.n76 VGND_uq0.n36 478.557
R1825 VGND_uq0.n76 VGND_uq0.n40 366.88
R1826 VGND_uq0.n114 VGND_uq0.n77 496.039
R1827 VGND_uq0.n105 VGND_uq0.n80 322.029
R1828 VGND_uq0.n98 VGND_uq0.n82 307.639
R1829 VGND_uq0.n97 VGND_uq0.n83 344.289
R1830 VGND_uq0.n96 VGND_uq0.n83 356.272
R1831 VGND_uq0.n92 VGND_uq0.n85 315.589
R1832 VGND_uq0.n91 VGND_uq0.n86 379.42
R1833 VGND_uq0.n89 VGND_uq0.n87 305.849
R1834 VGND_uq0.n90 VGND_uq0.n86 345.729
R1835 VGND_uq0.n93 VGND_uq0.n85 379.192
R1836 VGND_uq0.n94 VGND_uq0.n84 347.233
R1837 VGND_uq0.n99 VGND_uq0.n82 379.089
R1838 VGND_uq0.n100 VGND_uq0.n81 383.45
R1839 VGND_uq0.n103 VGND_uq0.n101 385.046
R1840 VGND_uq0.n102 VGND_uq0.n101 378.247
R1841 VGND_uq0.n106 VGND_uq0.n80 330.877
R1842 VGND_uq0.n109 VGND_uq0.n78 13.4878
R1843 VGND_uq0.n109 VGND_uq0.n77 513.938
R1844 VGND_uq0.n78 VGND_uq0.n77 1130.02
R1845 VGND_uq0.n107 VGND_uq0.n49 507.332
R1846 VGND_uq0.n108 VGND_uq0.n107 41.7113
R1847 VGND_uq0.n108 VGND_uq0.n79 573.37
R1848 VGND_uq0.n107 VGND_uq0.n79 874.663
R1849 VGND_uq0.n110 VGND_uq0.n111 41.7113
R1850 VGND_uq0.n110 VGND_uq0.n112 573.37
R1851 VGND_uq0.n111 VGND_uq0.n112 874.663
R1852 VGND_uq0.n78 VGND_uq0.n113 855.91
R1853 VGND_uq0.n117 VGND_uq0.n48 684.759
R1854 VGND_uq0.n120 VGND_uq0.n42 507.332
R1855 VGND_uq0.n121 VGND_uq0.n46 507.332
R1856 VGND_uq0.n128 VGND_uq0.n127 684.759
R1857 VGND_uq0.n129 VGND_uq0.n128 39.7242
R1858 VGND_uq0.n129 VGND_uq2 51.8839
R1859 VGND_uq0.n128 VGND_uq2 20.1185
R1860 VGND_uq0.n132 VGND_uq0.n41 303.783
R1861 VGND_uq0.n132 VGND_uq0.n131 303.783
R1862 VGND_uq0.n41 VGND_uq0.n131 7.65982
R1863 VGND_uq0.n135 VGND_uq0.n134 78.9199
R1864 VGND_uq0.n135 VGND_uq0.n38 689.476
R1865 VGND_uq0.n134 VGND_uq0.n38 1214.19
R1866 VGND_uq0.n141 VGND_uq0.n32 331.223
R1867 VGND_uq0.n143 VGND_uq0.n31 328.817
R1868 VGND_uq0.n145 VGND_uq0.n30 335.56
R1869 VGND_uq0.n149 VGND_uq0.n29 339.921
R1870 VGND_uq0.n151 VGND_uq0.n28 362.486
R1871 VGND_uq0.n153 VGND_uq0.n27 329.122
R1872 VGND_uq0.n163 VGND_uq0.n26 292.284
R1873 VGND_uq0.n162 VGND_uq0.n161 231.605
R1874 VGND_uq2 VGND_uq2 7945.89
R1875 VGND_uq2 VGND_uq0.n157 1988.65
R1876 VGND_uq2 VGND_uq0.n157 15060.7
R1877 VGND_uq2 VGND_uq2 9513.49
R1878 VGND_uq2 VGND_uq2 14482
R1879 VGND_uq2 VGND_uq2 9136.78
R1880 VGND_uq2 VGND_uq0.n158 1952.09
R1881 VGND_uq2 VGND_uq2 4900.03
R1882 VGND_uq2 VGND_uq0.n9 6332.43
R1883 VGND_uq2 VGND_uq0.n9 2621.5
R1884 VGND_uq2 VGND_uq2 8871.24
R1885 VGND_uq2 VGND_uq0.n159 11569.7
R1886 VGND_uq2 VGND_uq0.n159 2361.61
R1887 VGND_uq2 VGND_uq2 10247.1
R1888 VGND_uq2 VGND_uq2 2196.74
R1889 VGND_uq2 VGND_uq0.n160 4209.6
R1890 VGND_uq2 VGND_uq0.n160 2549.15
R1891 VGND_uq2 VGND_uq2 2971.2
R1892 VGND_uq2 VGND_uq2 9744.02
R1893 VGND_uq2 VGND_uq0.n161 1293.24
R1894 VGND_uq0.n167 VGND_uq2 30.7498
R1895 VGND_uq0.n24 VGND_uq0.n170 619.005
R1896 VGND_uq0.n172 VGND_uq0.n23 356.082
R1897 VGND_uq0.n177 VGND_uq0.n176 42.3942
R1898 VGND_uq0.n177 VGND_uq2 38.9651
R1899 VGND_uq0.n176 VGND_uq2 25.6601
R1900 VGND_uq0.n181 VGND_uq2 25.4527
R1901 VGND_uq0.n184 VGND_uq0.n18 377.05
R1902 VGND_uq0.n186 VGND_uq0.n17 386.281
R1903 VGND_uq0.n189 VGND_uq0.n16 348.418
R1904 VGND_uq0.n190 VGND_uq0.n15 343.779
R1905 VGND_uq0.n193 VGND_uq0.n14 379.721
R1906 VGND_uq0.n195 VGND_uq0.n13 348.221
R1907 VGND_uq0.n196 VGND_uq0.n12 343.834
R1908 VGND_uq0.n199 VGND_uq0.n11 379.291
R1909 VGND_uq0.n201 VGND_uq0.n10 312.399
R1910 VGND_uq0.n157 VGND_uq2 2260.2
R1911 VGND_uq2 VGND_uq2 2473.72
R1912 VGND_uq0.n35 VGND_uq0.n36 603.107
R1913 VGND_uq0.n35 VGND_uq0.n137 1585.25
R1914 VGND_uq0.n36 VGND_uq0.n137 1600.95
R1915 VGND_uq0.n139 VGND_uq0.n135 1904.61
R1916 VGND_uq0.n140 VGND_uq0.n135 125.02
R1917 VGND_uq0.n140 VGND_uq0.n33 1904.61
R1918 VGND_uq0.n135 VGND_uq0.n33 591.145
R1919 VGND_uq0.n40 VGND_uq0.n132 808.794
R1920 VGND_uq0.n127 VGND_uq0.n20 1246.43
R1921 VGND_uq0.n127 VGND_uq0.n124 1915.88
R1922 VGND_uq0.n20 VGND_uq0.n124 1915.88
R1923 VGND_uq0.n49 VGND_uq0.n119 1246.43
R1924 VGND_uq0.n49 VGND_uq0.n47 1915.88
R1925 VGND_uq0.n119 VGND_uq0.n47 1915.88
R1926 VGND_uq0.n66 VGND_uq0.n64 1908.01
R1927 VGND_uq0.n68 VGND_uq0.n64 122.788
R1928 VGND_uq0.n68 VGND_uq0.n53 1908.01
R1929 VGND_uq0.n64 VGND_uq0.n53 476.752
R1930 VGND_uq0.n66 VGND_uq0.n67 1007.37
R1931 VGND_uq0.n68 VGND_uq0.n67 1191.73
R1932 VGND_uq0.n74 VGND_uq2 984.059
R1933 VGND_uq0.n36 VGND_uq0.n40 630.952
R1934 VGND_uq0.n36 VGND_uq0.n37 1616.47
R1935 VGND_uq0.n40 VGND_uq0.n37 936.345
R1936 VGND_uq0.n76 VGND_uq0.n37 4182.33
R1937 VGND_uq0.n8 VGND_uq0.n88 228.008
R1938 VGND_uq0.n8 VGND_uq0.n87 2512.91
R1939 VGND_uq0.n88 VGND_uq0.n87 262.587
R1940 VGND_uq0.n89 VGND_uq0.n88 404.161
R1941 VGND_uq0.n84 VGND_uq0.n95 328.104
R1942 VGND_uq0.n84 VGND_uq0.n7 60284.7
R1943 VGND_uq0.n95 VGND_uq0.n7 1441.81
R1944 VGND_uq0.n81 VGND_uq0.n104 336.618
R1945 VGND_uq0.n81 VGND_uq0.n6 112172
R1946 VGND_uq0.n104 VGND_uq0.n6 1319.81
R1947 VGND_uq0.n102 VGND_uq0.n105 29.2861
R1948 VGND_uq0.n79 VGND_uq0.n49 1318.72
R1949 VGND_uq0.n79 VGND_uq0.n3 739.386
R1950 VGND_uq0.n49 VGND_uq0.n3 894.534
R1951 VGND_uq0.n107 VGND_uq0.n3 2907.18
R1952 VGND_uq0.n48 VGND_uq0.n43 1246.43
R1953 VGND_uq0.n48 VGND_uq0.n118 1915.88
R1954 VGND_uq0.n43 VGND_uq0.n118 1915.88
R1955 VGND_uq0.n119 VGND_uq0.n42 1318.72
R1956 VGND_uq0.n119 VGND_uq0.n41 1958
R1957 VGND_uq0.n42 VGND_uq0.n41 1958
R1958 VGND_uq0.n120 VGND_uq0.n41 2907.18
R1959 VGND_uq0.n42 VGND_uq0.n46 1246.43
R1960 VGND_uq0.n42 VGND_uq0.n45 1915.88
R1961 VGND_uq0.n46 VGND_uq0.n45 1915.88
R1962 VGND_uq0.n46 VGND_uq0.n1 1318.72
R1963 VGND_uq0.n46 VGND_uq0.n124 1958
R1964 VGND_uq0.n1 VGND_uq0.n124 1958
R1965 VGND_uq0.n121 VGND_uq0.n124 2907.18
R1966 VGND_uq0.n125 VGND_uq0.n39 545.237
R1967 VGND_uq0.n19 VGND_uq0.n123 1908.01
R1968 VGND_uq0.n183 VGND_uq0.n123 122.788
R1969 VGND_uq0.n183 VGND_uq0.n122 1908.01
R1970 VGND_uq0.n123 VGND_uq0.n122 466.219
R1971 VGND_uq0.n122 VGND_uq0.n2 1279.26
R1972 VGND_uq0.n123 VGND_uq0.n2 2458.38
R1973 VGND_uq0.n37 VGND_uq0.n132 1895.51
R1974 VGND_uq0.n37 VGND_uq0.n133 2195.79
R1975 VGND_uq0.n40 VGND_uq0.n133 2518.7
R1976 VGND_uq0.n132 VGND_uq0.n133 2174.26
R1977 VGND_uq0.n33 VGND_uq0.n38 630.952
R1978 VGND_uq0.n33 VGND_uq0.n136 1632.47
R1979 VGND_uq0.n38 VGND_uq0.n136 1616.47
R1980 VGND_uq0.n135 VGND_uq0.n136 4182.33
R1981 VGND_uq0.n145 VGND_uq0.n146 1310.25
R1982 VGND_uq0.n165 VGND_uq2 2718.77
R1983 VGND_uq0.n165 VGND_uq0.n147 4763.14
R1984 VGND_uq2 VGND_uq0.n147 498.538
R1985 VGND_uq2 VGND_uq2 2020.13
R1986 VGND_uq2 VGND_uq2 9669.71
R1987 VGND_uq2 VGND_uq2 9125.54
R1988 VGND_uq2 VGND_uq2 43648.7
R1989 VGND_uq2 VGND_uq0.n24 1555.05
R1990 VGND_uq2 VGND_uq2 14791.5
R1991 VGND_uq0.n158 VGND_uq2 529.428
R1992 VGND_uq0.n155 VGND_uq2 113598
R1993 VGND_uq2 VGND_uq2 3761.95
R1994 VGND_uq2 VGND_uq2 14233
R1995 VGND_uq0.n160 VGND_uq0.n9 6043
R1996 VGND_uq0.n9 VGND_uq2 101.859
R1997 VGND_uq0.n158 VGND_uq2 7251.69
R1998 VGND_uq2 VGND_uq2 2603.82
R1999 VGND_uq2 VGND_uq2 7443.12
R2000 VGND_uq2 VGND_uq2 2260.51
R2001 VGND_uq2 VGND_uq2 37420.4
R2002 VGND_uq2 VGND_uq2 11364.8
R2003 VGND_uq0.n67 VGND_uq2 45506.3
R2004 VGND_uq0.n67 VGND_uq2 10073.8
R2005 VGND_uq0.n65 VGND_uq2 8030.53
R2006 VGND_uq0.n65 VGND_uq2 1777.73
R2007 VGND_uq0.n156 VGND_uq0.n168 16463.2
R2008 VGND_uq0.n170 VGND_uq0.n171 1071.66
R2009 VGND_uq0.n24 VGND_uq0.n171 236.065
R2010 VGND_uq0.n19 VGND_uq2 892.813
R2011 VGND_uq0.n183 VGND_uq2 914.24
R2012 VGND_uq0.n18 VGND_uq0.n185 324.923
R2013 VGND_uq0.n187 VGND_uq0.n188 28.0126
R2014 VGND_uq0.n15 VGND_uq0.n191 327.93
R2015 VGND_uq0.n190 VGND_uq0.n191 827.952
R2016 VGND_uq0.n15 VGND_uq0.n0 74901.3
R2017 VGND_uq0.n191 VGND_uq0.n0 1385.84
R2018 VGND_uq0.n12 VGND_uq0.n197 331.901
R2019 VGND_uq0.n196 VGND_uq0.n197 814.602
R2020 VGND_uq0.n197 VGND_uq0.n5 1267.17
R2021 VGND_uq2 VGND_uq0.n0 1192.93
R2022 VGND_uq0.n173 VGND_uq0.n172 1403.41
R2023 VGND_uq0.n173 VGND_uq0.n175 605.319
R2024 VGND_uq0.n172 VGND_uq0.n174 774.119
R2025 VGND_uq0.n172 VGND_uq0.n175 212.171
R2026 VGND_uq0.n156 VGND_uq0.n169 31735.5
R2027 VGND_uq0.n156 VGND_uq0.n170 48824.8
R2028 VGND_uq0.n145 VGND_uq0.n147 863.442
R2029 VGND_uq0.n145 VGND_uq0.n148 169.325
R2030 VGND_uq0.n124 VGND_uq0.n128 6276.49
R2031 VGND_uq0.n124 VGND_uq0.n177 6276.49
R2032 VGND_uq0.n127 VGND_uq0.n177 1602.64
R2033 VGND_uq0.n128 VGND_uq0.n20 1602.64
R2034 VGND_uq0.n128 VGND_uq0.n177 112.957
R2035 VGND_uq0.n59 VGND_uq0.n58 1958.46
R2036 VGND_uq0.n59 VGND_uq0.n60 1684.19
R2037 VGND_uq0.n56 VGND_uq0.n60 1384.57
R2038 VGND_uq0.n58 VGND_uq0.n60 2105.36
R2039 VGND_uq0.n60 VGND_uq0.n61 2610.89
R2040 VGND_uq0.n59 VGND_uq0.n55 929.741
R2041 VGND_uq0.n59 VGND_uq0.n61 169.47
R2042 VGND_uq0.n61 VGND_uq0.n62 1684.19
R2043 VGND_uq0.n55 VGND_uq0.n62 1384.57
R2044 VGND_uq0.n60 VGND_uq0.n62 2105.36
R2045 VGND_uq0.n62 VGND_uq0.n63 2598
R2046 VGND_uq0.n61 VGND_uq0.n54 929.741
R2047 VGND_uq0.n61 VGND_uq0.n63 169.47
R2048 VGND_uq0.n68 VGND_uq0.n69 159.202
R2049 VGND_uq0.n69 VGND_uq0.n70 2119.96
R2050 VGND_uq0.n70 VGND_uq0.n71 1684.19
R2051 VGND_uq0.n52 VGND_uq0.n71 929.741
R2052 VGND_uq0.n69 VGND_uq0.n71 169.47
R2053 VGND_uq0.n71 VGND_uq0.n72 2610.89
R2054 VGND_uq0.n70 VGND_uq0.n51 1384.57
R2055 VGND_uq0.n70 VGND_uq0.n72 2105.36
R2056 VGND_uq0.n72 VGND_uq0.n73 1684.19
R2057 VGND_uq0.n51 VGND_uq0.n73 929.741
R2058 VGND_uq0.n71 VGND_uq0.n73 169.47
R2059 VGND_uq0.n73 VGND_uq0.n74 2263.19
R2060 VGND_uq0.n72 VGND_uq0.n50 1384.57
R2061 VGND_uq0.n72 VGND_uq0.n74 2105.36
R2062 VGND_uq0.n74 VGND_uq0.n75 2131.17
R2063 VGND_uq0.n50 VGND_uq0.n75 1128.36
R2064 VGND_uq0.n73 VGND_uq0.n75 209.697
R2065 VGND_uq2 VGND_uq0.n35 1974.85
R2066 VGND_uq2 VGND_uq0.n75 3359.43
R2067 VGND_uq0.n74 VGND_uq0.n35 2615.4
R2068 VGND_uq0.n137 VGND_uq0.n76 9396.33
R2069 VGND_uq0.n137 VGND_uq0.n75 9396.33
R2070 VGND_uq0.n36 VGND_uq0.n75 1564.36
R2071 VGND_uq0.n76 VGND_uq0.n35 1549.02
R2072 VGND_uq0.n76 VGND_uq0.n75 177.306
R2073 VGND_uq0.n132 VGND_uq0.n76 3485.43
R2074 VGND_uq0.n89 VGND_uq0.n86 957.846
R2075 VGND_uq0.n89 VGND_uq0.n91 169.862
R2076 VGND_uq0.n90 VGND_uq0.n91 1020.26
R2077 VGND_uq0.n91 VGND_uq0.n93 162.758
R2078 VGND_uq0.n92 VGND_uq0.n93 916.792
R2079 VGND_uq0.n85 VGND_uq0.n94 947.346
R2080 VGND_uq0.n93 VGND_uq0.n94 169.798
R2081 VGND_uq0.n95 VGND_uq0.n83 886.521
R2082 VGND_uq0.n95 VGND_uq0.n96 45.0253
R2083 VGND_uq0.n95 VGND_uq0.n94 1077.2
R2084 VGND_uq0.n96 VGND_uq0.n97 871.702
R2085 VGND_uq0.n97 VGND_uq0.n99 162.346
R2086 VGND_uq0.n98 VGND_uq0.n99 1015.15
R2087 VGND_uq0.n82 VGND_uq0.n100 952.001
R2088 VGND_uq0.n99 VGND_uq0.n100 169.81
R2089 VGND_uq0.n102 VGND_uq0.n103 1943.6
R2090 VGND_uq0.n102 VGND_uq0.n106 1715.57
R2091 VGND_uq0.n101 VGND_uq0.n106 966.385
R2092 VGND_uq0.n103 VGND_uq0.n106 170.319
R2093 VGND_uq0.n103 VGND_uq0.n104 1367.86
R2094 VGND_uq0.n101 VGND_uq0.n104 900.226
R2095 VGND_uq0.n102 VGND_uq0.n104 46.2665
R2096 VGND_uq0.n104 VGND_uq0.n100 1412.67
R2097 VGND_uq0.n103 VGND_uq0.n81 962.066
R2098 VGND_uq0.n103 VGND_uq0.n100 169.868
R2099 VGND_uq0.n105 VGND_uq0.n106 1049.74
R2100 VGND_uq0.n102 VGND_uq0.n80 2140.5
R2101 VGND_uq0.n47 VGND_uq0.n107 6276.49
R2102 VGND_uq0.n47 VGND_uq0.n120 6276.49
R2103 VGND_uq0.n49 VGND_uq0.n120 1602.64
R2104 VGND_uq0.n107 VGND_uq0.n119 1602.64
R2105 VGND_uq0.n107 VGND_uq0.n120 112.957
R2106 VGND_uq0.n109 VGND_uq0.n108 261.036
R2107 VGND_uq0.n109 VGND_uq0.n110 261.036
R2108 VGND_uq0.n118 VGND_uq0.n117 6276.49
R2109 VGND_uq0.n118 VGND_uq0.n129 6276.49
R2110 VGND_uq0.n48 VGND_uq0.n129 1602.64
R2111 VGND_uq0.n117 VGND_uq0.n43 1602.64
R2112 VGND_uq0.n117 VGND_uq0.n129 112.957
R2113 VGND_uq0.n45 VGND_uq0.n121 6276.49
R2114 VGND_uq0.n45 VGND_uq0.n120 6276.49
R2115 VGND_uq0.n46 VGND_uq0.n120 1602.64
R2116 VGND_uq0.n121 VGND_uq0.n42 1602.64
R2117 VGND_uq0.n121 VGND_uq0.n120 112.957
R2118 VGND_uq0.n125 VGND_uq0.n134 346.384
R2119 VGND_uq0.n134 VGND_uq0.n123 6336.32
R2120 VGND_uq0.n39 VGND_uq0.n123 30291.3
R2121 VGND_uq0.n125 VGND_uq0.n123 281.599
R2122 VGND_uq2 VGND_uq0.n139 1360.59
R2123 VGND_uq2 VGND_uq0.n140 1764.51
R2124 VGND_uq0.n140 VGND_uq0.n141 193.446
R2125 VGND_uq0.n141 VGND_uq0.n142 1994.83
R2126 VGND_uq0.n142 VGND_uq0.n143 1684.19
R2127 VGND_uq0.n32 VGND_uq0.n143 929.741
R2128 VGND_uq0.n141 VGND_uq0.n143 169.47
R2129 VGND_uq0.n143 VGND_uq0.n144 1853.91
R2130 VGND_uq0.n142 VGND_uq0.n31 1384.57
R2131 VGND_uq0.n142 VGND_uq0.n144 2105.36
R2132 VGND_uq0.n144 VGND_uq0.n30 1295.83
R2133 VGND_uq0.n144 VGND_uq0.n146 2094.31
R2134 VGND_uq2 VGND_uq0.n148 1173.21
R2135 VGND_uq0.n148 VGND_uq0.n149 158.627
R2136 VGND_uq0.n149 VGND_uq0.n150 2111.58
R2137 VGND_uq0.n150 VGND_uq0.n151 1684.19
R2138 VGND_uq0.n29 VGND_uq0.n151 929.741
R2139 VGND_uq0.n149 VGND_uq0.n151 169.47
R2140 VGND_uq0.n151 VGND_uq0.n152 2610.89
R2141 VGND_uq0.n150 VGND_uq0.n28 1384.57
R2142 VGND_uq0.n150 VGND_uq0.n152 2105.36
R2143 VGND_uq0.n152 VGND_uq0.n153 1684.19
R2144 VGND_uq0.n28 VGND_uq0.n153 929.741
R2145 VGND_uq0.n151 VGND_uq0.n153 169.47
R2146 VGND_uq0.n153 VGND_uq0.n154 1891.69
R2147 VGND_uq0.n152 VGND_uq0.n27 1384.57
R2148 VGND_uq0.n152 VGND_uq0.n154 2105.36
R2149 VGND_uq0.n154 VGND_uq0.n26 1645
R2150 VGND_uq0.n154 VGND_uq0.n164 1334.77
R2151 VGND_uq2 VGND_uq2 30305
R2152 VGND_uq2 VGND_uq2 11607.7
R2153 VGND_uq2 VGND_uq2 10794.5
R2154 VGND_uq0.n164 VGND_uq0.n163 1666.23
R2155 VGND_uq0.n156 VGND_uq0.n25 62108.4
R2156 VGND_uq0.n172 VGND_uq0.n171 2071.17
R2157 VGND_uq0.n173 VGND_uq0.n23 1056.42
R2158 VGND_uq0.n173 VGND_uq0.n171 460.743
R2159 VGND_uq0.n182 VGND_uq0.n176 1021.88
R2160 VGND_uq0.n182 VGND_uq0.n22 2834.74
R2161 VGND_uq0.n183 VGND_uq0.n184 162.279
R2162 VGND_uq0.n185 VGND_uq0.n184 1181.7
R2163 VGND_uq0.n185 VGND_uq0.n186 1364.92
R2164 VGND_uq0.n18 VGND_uq0.n186 961.436
R2165 VGND_uq0.n184 VGND_uq0.n186 169.861
R2166 VGND_uq0.n186 VGND_uq0.n187 1956.62
R2167 VGND_uq0.n185 VGND_uq0.n17 906.734
R2168 VGND_uq0.n185 VGND_uq0.n187 46.2608
R2169 VGND_uq0.n187 VGND_uq0.n189 1778.81
R2170 VGND_uq0.n17 VGND_uq0.n189 959.775
R2171 VGND_uq0.n186 VGND_uq0.n189 170.386
R2172 VGND_uq0.n188 VGND_uq0.n189 1286.38
R2173 VGND_uq0.n187 VGND_uq0.n16 2287.42
R2174 VGND_uq0.n190 VGND_uq0.n193 162.431
R2175 VGND_uq0.n192 VGND_uq0.n193 950.803
R2176 VGND_uq0.n14 VGND_uq0.n195 949.914
R2177 VGND_uq0.n193 VGND_uq0.n195 169.821
R2178 VGND_uq0.n194 VGND_uq0.n195 1021.74
R2179 VGND_uq0.n196 VGND_uq0.n199 162.809
R2180 VGND_uq0.n198 VGND_uq0.n199 1015.89
R2181 VGND_uq0.n11 VGND_uq0.n201 952.462
R2182 VGND_uq0.n199 VGND_uq0.n201 169.825
R2183 VGND_uq0.n200 VGND_uq0.n201 456.241
R2184 VGND_uq0.n10 VGND_uq0.n199 8464.23
R2185 VGND_uq0.n10 VGND_uq0.n11 3174.85
R2186 VGND_uq0.n199 VGND_uq0.n200 6724.4
R2187 VGND_uq0.n200 VGND_uq0.n11 1446.44
R2188 VGND_uq0.n11 VGND_uq0.n196 5053.25
R2189 VGND_uq0.n196 VGND_uq0.n198 2273.94
R2190 VGND_uq0.n195 VGND_uq0.n12 1667.59
R2191 VGND_uq0.n12 VGND_uq0.n13 2459.11
R2192 VGND_uq0.n13 VGND_uq0.n193 8459.53
R2193 VGND_uq0.n13 VGND_uq0.n14 3153.05
R2194 VGND_uq0.n193 VGND_uq0.n194 6075.65
R2195 VGND_uq0.n194 VGND_uq0.n14 1145.69
R2196 VGND_uq0.n14 VGND_uq0.n190 5092.69
R2197 VGND_uq0.n190 VGND_uq0.n192 2057.38
R2198 VGND_uq0.n189 VGND_uq0.n15 1664.17
R2199 VGND_uq0.n15 VGND_uq0.n16 2405.97
R2200 VGND_uq0.n16 VGND_uq0.n186 8618.66
R2201 VGND_uq0.n16 VGND_uq0.n17 3281.65
R2202 VGND_uq0.n186 VGND_uq0.n188 11960.3
R2203 VGND_uq0.n188 VGND_uq0.n17 4554.02
R2204 VGND_uq0.n187 VGND_uq0.n184 19650.8
R2205 VGND_uq0.n187 VGND_uq0.n18 7506.26
R2206 VGND_uq0.n184 VGND_uq0.n17 8526.35
R2207 VGND_uq0.n17 VGND_uq0.n18 3256.91
R2208 VGND_uq0.n18 VGND_uq0.n183 4786.13
R2209 VGND_uq0.n171 VGND_uq0.n175 30910.7
R2210 VGND_uq0.n171 VGND_uq0.n174 9300.89
R2211 VGND_uq0.n175 VGND_uq0.n23 9608.2
R2212 VGND_uq0.n174 VGND_uq0.n23 2891.06
R2213 VGND_uq0.n23 VGND_uq0.n24 9740.48
R2214 VGND_uq0.n23 VGND_uq0.n169 1537.59
R2215 VGND_uq0.n23 VGND_uq0.n170 1276.81
R2216 VGND_uq0.n171 VGND_uq0.n169 4210.34
R2217 VGND_uq0.n24 VGND_uq0.n169 15462.3
R2218 VGND_uq0.n169 VGND_uq0.n25 1185.8
R2219 VGND_uq0.n169 VGND_uq0.n168 5200.9
R2220 VGND_uq0.n170 VGND_uq0.n25 5790.25
R2221 VGND_uq0.n170 VGND_uq0.n168 21316.2
R2222 VGND_uq0.n163 VGND_uq2 3428.96
R2223 VGND_uq0.n26 VGND_uq2 19928.7
R2224 VGND_uq0.n164 VGND_uq2 45097.5
R2225 VGND_uq0.n164 VGND_uq0.n153 9782.17
R2226 VGND_uq0.n164 VGND_uq0.n27 8402.62
R2227 VGND_uq0.n153 VGND_uq0.n26 1556.81
R2228 VGND_uq0.n26 VGND_uq0.n27 2217.02
R2229 VGND_uq0.n154 VGND_uq0.n151 37960
R2230 VGND_uq0.n154 VGND_uq0.n28 14500.1
R2231 VGND_uq0.n151 VGND_uq0.n27 6836.18
R2232 VGND_uq0.n27 VGND_uq0.n28 2611.3
R2233 VGND_uq0.n152 VGND_uq0.n149 37960
R2234 VGND_uq0.n152 VGND_uq0.n29 14500.1
R2235 VGND_uq0.n149 VGND_uq0.n28 6836.18
R2236 VGND_uq0.n28 VGND_uq0.n29 2611.3
R2237 VGND_uq0.n150 VGND_uq0.n148 8743.85
R2238 VGND_uq0.n148 VGND_uq0.n29 2758.07
R2239 VGND_uq0.n148 VGND_uq0.n30 7792.93
R2240 VGND_uq0.n148 VGND_uq0.n146 6344.94
R2241 VGND_uq0.n147 VGND_uq0.n30 2658.46
R2242 VGND_uq0.n147 VGND_uq0.n146 1429.68
R2243 VGND_uq0.n146 VGND_uq0.n143 15277.3
R2244 VGND_uq0.n146 VGND_uq0.n31 13151.2
R2245 VGND_uq0.n143 VGND_uq0.n30 1507.22
R2246 VGND_uq0.n30 VGND_uq0.n31 2102.68
R2247 VGND_uq0.n144 VGND_uq0.n141 37960
R2248 VGND_uq0.n144 VGND_uq0.n32 14500.1
R2249 VGND_uq0.n141 VGND_uq0.n31 6836.18
R2250 VGND_uq0.n31 VGND_uq0.n32 2611.3
R2251 VGND_uq0.n142 VGND_uq0.n140 9256.15
R2252 VGND_uq0.n140 VGND_uq0.n32 3062.08
R2253 VGND_uq0.n35 VGND_uq0.n73 7092.69
R2254 VGND_uq0.n35 VGND_uq0.n50 3555.67
R2255 VGND_uq0.n73 VGND_uq2 13708.2
R2256 VGND_uq2 VGND_uq0.n50 6872.14
R2257 VGND_uq0.n74 VGND_uq0.n71 37960
R2258 VGND_uq0.n74 VGND_uq0.n51 14500.1
R2259 VGND_uq0.n71 VGND_uq0.n50 6836.18
R2260 VGND_uq0.n50 VGND_uq0.n51 2611.3
R2261 VGND_uq0.n72 VGND_uq0.n69 37960
R2262 VGND_uq0.n72 VGND_uq0.n52 14500.1
R2263 VGND_uq0.n69 VGND_uq0.n51 6836.18
R2264 VGND_uq0.n51 VGND_uq0.n52 2611.3
R2265 VGND_uq0.n70 VGND_uq0.n68 8925.93
R2266 VGND_uq0.n68 VGND_uq0.n52 2792.65
R2267 VGND_uq0.n62 VGND_uq0.n53 5675.64
R2268 VGND_uq0.n62 VGND_uq0.n64 9931.15
R2269 VGND_uq0.n53 VGND_uq0.n54 1884.03
R2270 VGND_uq0.n53 VGND_uq0.n63 2711.09
R2271 VGND_uq0.n54 VGND_uq0.n64 2570.9
R2272 VGND_uq0.n63 VGND_uq0.n60 37960
R2273 VGND_uq0.n63 VGND_uq0.n55 6836.18
R2274 VGND_uq0.n60 VGND_uq0.n54 14500.1
R2275 VGND_uq0.n54 VGND_uq0.n55 2611.3
R2276 VGND_uq0.n61 VGND_uq0.n58 37960
R2277 VGND_uq0.n61 VGND_uq0.n56 6836.18
R2278 VGND_uq0.n58 VGND_uq0.n55 14500.1
R2279 VGND_uq0.n55 VGND_uq0.n56 2611.3
R2280 VGND_uq0.n56 VGND_uq0.n57 1086.61
R2281 VGND_uq0.n57 VGND_uq0.n58 1526.46
R2282 VGND_uq0.n56 VGND_uq0.n25 4813.36
R2283 VGND_uq0.n58 VGND_uq0.n25 2439.41
R2284 VGND_uq0.n25 VGND_uq0.n59 5974.31
R2285 VGND_uq0.n57 VGND_uq0.n59 221.476
R2286 VGND_uq0.n62 VGND_uq2 5104.29
R2287 VGND_uq0.n54 VGND_uq2 3376.9
R2288 VGND_uq0.n63 VGND_uq2 6808.61
R2289 VGND_uq0.n64 VGND_uq2 4651.74
R2290 VGND_uq0.n70 VGND_uq0.n67 5218.25
R2291 VGND_uq0.n52 VGND_uq0.n67 2811.28
R2292 VGND_uq0.n69 VGND_uq0.n67 2133.77
R2293 VGND_uq0.n115 VGND_uq0.n114 335.173
R2294 VGND_uq0.n80 VGND_uq0.n103 8591.83
R2295 VGND_uq0.n80 VGND_uq0.n101 3298.44
R2296 VGND_uq0.n103 VGND_uq0.n105 12472.7
R2297 VGND_uq0.n105 VGND_uq0.n101 4788.32
R2298 VGND_uq0.n100 VGND_uq0.n102 19695.5
R2299 VGND_uq0.n100 VGND_uq0.n101 8477.77
R2300 VGND_uq0.n102 VGND_uq0.n81 7523.33
R2301 VGND_uq0.n81 VGND_uq0.n101 3238.36
R2302 VGND_uq0.n99 VGND_uq0.n81 8263.51
R2303 VGND_uq0.n81 VGND_uq0.n82 3072.99
R2304 VGND_uq0.n82 VGND_uq0.n97 5008.32
R2305 VGND_uq0.n97 VGND_uq0.n98 2299.01
R2306 VGND_uq0.n94 VGND_uq0.n96 7896.19
R2307 VGND_uq0.n94 VGND_uq0.n83 1682.18
R2308 VGND_uq0.n96 VGND_uq0.n84 6680.93
R2309 VGND_uq0.n84 VGND_uq0.n83 2546.52
R2310 VGND_uq0.n93 VGND_uq0.n84 8221.06
R2311 VGND_uq0.n84 VGND_uq0.n85 3001.32
R2312 VGND_uq0.n85 VGND_uq0.n91 5039.3
R2313 VGND_uq0.n91 VGND_uq0.n92 1812.52
R2314 VGND_uq0.n91 VGND_uq0.n87 8583.67
R2315 VGND_uq0.n91 VGND_uq0.n88 5140.92
R2316 VGND_uq0.n86 VGND_uq0.n87 3253.8
R2317 VGND_uq0.n86 VGND_uq0.n88 1105.83
R2318 VGND_uq0.n87 VGND_uq0.n90 6787.7
R2319 VGND_uq0.n89 VGND_uq0.n90 4013.03
R2320 VGND_uq0.n90 VGND_uq0.n88 40.2738
R2321 VGND_uq0.n84 VGND_uq0.n92 1344.41
R2322 VGND_uq0.n94 VGND_uq0.n92 2033.06
R2323 VGND_uq0.n94 VGND_uq0.n97 298.844
R2324 VGND_uq0.n84 VGND_uq0.n97 1692.6
R2325 VGND_uq0.n95 VGND_uq0.n97 2429.31
R2326 VGND_uq0.n81 VGND_uq0.n98 1232.74
R2327 VGND_uq0.n100 VGND_uq0.n98 1866.84
R2328 VGND_uq0.n39 VGND_uq0.n2 1.80923e+06
R2329 VGND_uq0.n134 VGND_uq0.n2 378464
R2330 VGND_uq0.n134 VGND_uq0.n122 144828
R2331 VGND_uq0.n122 VGND_uq0.n125 1750.62
R2332 VGND_uq0.n143 VGND_uq0.n145 297.822
R2333 VGND_uq0.n31 VGND_uq0.n145 1632.62
R2334 VGND_uq0.n144 VGND_uq0.n145 2951.84
R2335 VGND_uq0.n153 VGND_uq0.n163 297.425
R2336 VGND_uq0.n27 VGND_uq0.n163 1636.2
R2337 VGND_uq0.n154 VGND_uq0.n163 3067.66
R2338 VGND_uq0.n162 VGND_uq2 1401.86
R2339 VGND_uq0.n169 VGND_uq0.n57 317.899
R2340 VGND_uq0.n170 VGND_uq0.n57 3514.14
R2341 VGND_uq0.n156 VGND_uq0.n57 76072.2
R2342 VGND_uq0.n168 VGND_uq0.n57 1753.52
R2343 VGND_uq0.n24 VGND_uq0.n172 19017.7
R2344 VGND_uq0.n170 VGND_uq0.n172 1523.93
R2345 VGND_uq0.n169 VGND_uq0.n172 232.751
R2346 VGND_uq0.n15 VGND_uq0.n188 1227.81
R2347 VGND_uq0.n188 VGND_uq0.n190 3443.83
R2348 VGND_uq0.n189 VGND_uq0.n190 298.644
R2349 VGND_uq0.n16 VGND_uq0.n190 1669.66
R2350 VGND_uq0.n14 VGND_uq0.n191 4274.76
R2351 VGND_uq0.n193 VGND_uq0.n191 1930.15
R2352 VGND_uq0.n192 VGND_uq0.n191 46.6294
R2353 VGND_uq0.n13 VGND_uq0.n192 3237.04
R2354 VGND_uq0.n195 VGND_uq0.n192 2762.97
R2355 VGND_uq0.n194 VGND_uq0.n192 56.3201
R2356 VGND_uq0.n12 VGND_uq0.n194 1122.89
R2357 VGND_uq0.n194 VGND_uq0.n196 3152.69
R2358 VGND_uq0.n195 VGND_uq0.n196 298.683
R2359 VGND_uq0.n13 VGND_uq0.n196 1678.66
R2360 VGND_uq0.n11 VGND_uq0.n197 3127.67
R2361 VGND_uq0.n199 VGND_uq0.n197 1682.85
R2362 VGND_uq0.n198 VGND_uq0.n197 51.6164
R2363 VGND_uq0.n10 VGND_uq0.n198 2799.62
R2364 VGND_uq0.n201 VGND_uq0.n198 2431.65
R2365 VGND_uq0.n200 VGND_uq0.n198 52.6785
R2366 VGND_uq0.n198 VGND_uq0.n12 5362.86
R2367 VGND_uq0.n11 VGND_uq0.n12 17062.6
R2368 VGND_uq0.n199 VGND_uq0.n12 5091.7
R2369 VGND_uq0.n192 VGND_uq0.n15 4848.11
R2370 VGND_uq0.n14 VGND_uq0.n15 17242.7
R2371 VGND_uq0.n193 VGND_uq0.n15 5100.98
R2372 VGND_uq0.n52 VGND_uq0.n66 7928.81
R2373 VGND_uq0.n70 VGND_uq0.n66 22081
R2374 VGND_uq0.n69 VGND_uq0.n66 3836.63
R2375 VGND_uq0.n59 VGND_uq0.n168 13506.8
R2376 VGND_uq0.n56 VGND_uq0.n168 10020.1
R2377 VGND_uq0.n58 VGND_uq0.n168 2170.52
R2378 VGND_uq0.n108 VGND_uq0.n78 2136.58
R2379 VGND_uq0.n109 VGND_uq0.n112 4981.96
R2380 VGND_uq0.n110 VGND_uq0.n78 2136.58
R2381 VGND_uq0.n112 VGND_uq0.n78 666.588
R2382 VGND_uq0.n6 VGND_uq0.n105 1021.94
R2383 VGND_uq0.n112 VGND_uq0.n79 91880.8
R2384 VGND_uq0.n109 VGND_uq0.n79 4981.96
R2385 VGND_uq0.n79 VGND_uq0.n78 666.588
R2386 VGND_uq0.n113 VGND_uq0.n79 149214
R2387 VGND_uq0.n113 VGND_uq0.n3 761.255
R2388 VGND_uq0.n113 VGND_uq0.n112 149214
R2389 VGND_uq0.n78 VGND_uq0.n3 15.4081
R2390 VGND_uq0.n3 VGND_uq0.n112 739.388
R2391 VGND_uq0.n22 VGND_uq2 5809.86
R2392 VGND_uq0.n176 VGND_uq2 188.429
R2393 VGND_uq0.n182 VGND_uq2 148.29
R2394 VGND_uq0.n112 VGND_uq0.n116 1318.72
R2395 VGND_uq0.n116 VGND_uq0.n111 1958
R2396 VGND_uq0.n116 VGND_uq0.n3 894.534
R2397 VGND_uq0.n111 VGND_uq0.n3 2907.18
R2398 VGND_uq0.n3 VGND_uq0.n115 11.8638
R2399 VGND_uq0.n49 VGND_uq0.n115 920.366
R2400 VGND_uq0.n49 VGND_uq0.n116 127377
R2401 VGND_uq0.n115 VGND_uq0.n116 920.366
R2402 VGND_uq0.n115 VGND_uq0.n113 1446.34
R2403 VGND_uq0.n114 VGND_uq0.n3 2941.93
R2404 VGND_uq0.n29 VGND_uq0.n147 7588.71
R2405 VGND_uq0.n29 VGND_uq2 2930.16
R2406 VGND_uq0.n150 VGND_uq0.n147 20731.4
R2407 VGND_uq0.n150 VGND_uq2 5438.57
R2408 VGND_uq0.n149 VGND_uq0.n147 3728.96
R2409 VGND_uq0.n149 VGND_uq2 2225.62
R2410 VGND_uq0.n32 VGND_uq0.n139 7393.92
R2411 VGND_uq0.n32 VGND_uq2 3687.95
R2412 VGND_uq0.n142 VGND_uq0.n139 18537.3
R2413 VGND_uq0.n142 VGND_uq2 6885.43
R2414 VGND_uq0.n141 VGND_uq0.n139 3317.27
R2415 VGND_uq0.n141 VGND_uq2 2444.18
R2416 VGND_uq0.n98 VGND_uq0.n83 5091.69
R2417 VGND_uq0.n98 VGND_uq0.n96 55.5404
R2418 VGND_uq0.n82 VGND_uq0.n83 16769.1
R2419 VGND_uq0.n82 VGND_uq0.n96 2805.79
R2420 VGND_uq0.n99 VGND_uq0.n83 5055
R2421 VGND_uq0.n99 VGND_uq0.n96 1612.2
R2422 VGND_uq0.n92 VGND_uq0.n86 3368.66
R2423 VGND_uq0.n92 VGND_uq0.n90 55.5922
R2424 VGND_uq0.n85 VGND_uq0.n86 16748.6
R2425 VGND_uq0.n85 VGND_uq0.n90 3951.85
R2426 VGND_uq0.n93 VGND_uq0.n86 5027.65
R2427 VGND_uq0.n93 VGND_uq0.n90 1996.74
R2428 VGND_uq0.n89 VGND_uq0.n8 1262.43
R2429 VGND_uq0.n92 VGND_uq0.n7 1839.66
R2430 VGND_uq0.n92 VGND_uq0.n95 68.9135
R2431 VGND_uq0.n85 VGND_uq0.n7 195583
R2432 VGND_uq0.n85 VGND_uq0.n95 1641.86
R2433 VGND_uq0.n93 VGND_uq0.n95 8145.86
R2434 VGND_uq0.n7 VGND_uq0.n94 248959
R2435 VGND_uq0.n98 VGND_uq0.n104 63.159
R2436 VGND_uq0.n82 VGND_uq0.n104 2184.98
R2437 VGND_uq0.n99 VGND_uq0.n104 9039.56
R2438 VGND_uq0.n30 VGND_uq2 16387
R2439 VGND_uq0.n30 VGND_uq0.n165 65057.9
R2440 VGND_uq0.n148 VGND_uq0.n165 78776.5
R2441 VGND_uq0.n145 VGND_uq2 9521.01
R2442 VGND_uq0.n145 VGND_uq0.n165 37799.2
R2443 VGND_uq2 VGND_uq0.n146 2297.69
R2444 VGND_uq0.n146 VGND_uq0.n165 9122.02
R2445 VGND_uq0.n162 VGND_uq0.n163 484.296
R2446 VGND_uq0.n161 VGND_uq0.n163 2936.13
R2447 VGND_uq0.n161 VGND_uq0.n164 83508.7
R2448 VGND_uq0.n161 VGND_uq0.n26 32222.3
R2449 VGND_uq0.n162 VGND_uq0.n164 16289.8
R2450 VGND_uq0.n162 VGND_uq0.n26 6160.23
R2451 VGND_uq0.n18 VGND_uq0.n0 64420
R2452 VGND_uq0.n18 VGND_uq2 1233.26
R2453 VGND_uq0.n184 VGND_uq0.n0 143627
R2454 VGND_uq0.n184 VGND_uq2 1257.56
R2455 VGND_uq0.n183 VGND_uq0.n0 188754
R2456 VGND_uq2 VGND_uq0.n185 71.4767
R2457 VGND_uq0.n183 VGND_uq0.n185 3244.03
R2458 VGND_uq0.n188 VGND_uq0.n191 66.2782
R2459 VGND_uq0.n16 VGND_uq0.n191 1767.44
R2460 VGND_uq0.n189 VGND_uq0.n191 4195.42
R2461 VGND_uq0.n194 VGND_uq0.n5 1706.42
R2462 VGND_uq0.n194 VGND_uq0.n197 60.5303
R2463 VGND_uq0.n13 VGND_uq0.n197 2500.14
R2464 VGND_uq0.n195 VGND_uq0.n197 4634.28
R2465 VGND_uq0.n192 VGND_uq0.n0 3235.14
R2466 VGND_uq0.n192 VGND_uq0.n5 1859.72
R2467 VGND_uq0.n0 VGND_uq0.n5 3.42959
R2468 VGND_uq0.n0 VGND_uq0.n194 3235.14
R2469 VGND_uq0.n90 VGND_uq0.n8 2351.25
R2470 VGND_uq0.n90 VGND_uq0.n7 2371.01
R2471 VGND_uq0.n8 VGND_uq0.n7 2.49271
R2472 VGND_uq0.n8 VGND_uq0.n92 2351.25
R2473 VGND_uq0.n185 VGND_uq0.n19 7695.67
R2474 VGND_uq0.n18 VGND_uq0.n19 15801.8
R2475 VGND_uq0.n184 VGND_uq0.n19 5038.6
R2476 VGND_uq0.n201 VGND_uq0.n4 1705.17
R2477 VGND_uq0.n10 VGND_uq0.n4 5086.87
R2478 VGND_uq0.n6 VGND_uq0.n114 196433
R2479 VGND_uq0.n6 VGND_uq0.n77 167009
R2480 VGND_uq0.n105 VGND_uq0.n114 2630.67
R2481 VGND_uq0.n105 VGND_uq0.n77 3567.46
R2482 VGND_uq0.n80 VGND_uq0.n114 2242.15
R2483 VGND_uq0.n80 VGND_uq0.n77 6789.51
R2484 VGND_uq0.n106 VGND_uq0.n114 458.906
R2485 VGND_uq0.n106 VGND_uq0.n77 2270.4
R2486 VGND_uq0.n106 VGND_uq0.n109 1726.39
R2487 VGND_uq0.n80 VGND_uq0.n109 1563.6
R2488 VGND_uq0.n105 VGND_uq0.n109 68.6959
R2489 VGND_uq0.n6 VGND_uq0.n109 1460.07
R2490 VGND_uq0.n114 VGND_uq0.n109 1398.44
R2491 VGND_uq0.n182 VGND_uq0.n180 4635.24
R2492 VGND_uq0.n180 VGND_uq0.n21 1508.69
R2493 VGND_uq2 VGND_uq2 57528.1
R2494 VGND_uq2 VGND_uq2 17399.2
R2495 VGND_uq2 VGND_uq2 6648.19
R2496 VGND_uq2 VGND_uq2 2010.72
R2497 VGND_uq2 VGND_uq2 20535.1
R2498 VGND_uq2 VGND_uq2 112147
R2499 VGND_uq2 VGND_uq2 2330
R2500 VGND_uq2 VGND_uq2 2753.98
R2501 VGND_uq2 VGND_uq2 15071.6
R2502 VGND_uq2 VGND_uq2 15841.7
R2503 VGND_uq2 VGND_uq2 86696.4
R2504 VGND_uq2 VGND_uq2 8244.14
R2505 VGND_uq2 VGND_uq2 1938.22
R2506 VGND_uq2 VGND_uq2 129864
R2507 VGND_uq2 VGND_uq2 30531.4
R2508 VGND_uq0.n76 VGND_uq0.n115 378.82
R2509 VGND_uq0.n132 VGND_uq0.n115 2880.36
R2510 VGND_uq0.n40 VGND_uq0.n115 933.236
R2511 VGND_uq0.n21 VGND_uq2 3523.12
R2512 VGND_uq0.n21 VGND_uq0.n181 5847.36
R2513 VGND_uq0.n180 VGND_uq2 2372.84
R2514 VGND_uq0.n182 VGND_uq2 430.438
R2515 VGND_uq0.n182 VGND_uq0.n181 714.4
R2516 VGND_uq0.n113 VGND_uq0.n76 99650.4
R2517 VGND_uq0.n114 VGND_uq0.n76 9202.99
R2518 VGND_uq0.n114 VGND_uq0.n40 46857.5
R2519 VGND_uq0.n114 VGND_uq0.n132 182094
R2520 VGND_uq0.n162 VGND_uq0.n4 1001.38
R2521 VGND_uq0.n161 VGND_uq0.n4 1749.45
R2522 VGND_uq2 VGND_uq0.n4 502.221
R2523 VGND_uq0.n173 VGND_uq0.n8 1826.14
R2524 VGND_uq0.n175 VGND_uq0.n8 634.884
R2525 VGND_uq0.n174 VGND_uq0.n8 4920.25
R2526 VGND_uq0.n89 VGND_uq0.n173 21977.1
R2527 VGND_uq0.n89 VGND_uq0.n175 11691.9
R2528 VGND_uq0.n89 VGND_uq0.n174 63464.3
R2529 VGND_uq0.n201 VGND_uq0.n162 26651.3
R2530 VGND_uq0.n201 VGND_uq0.n161 39230
R2531 VGND_uq0.n201 VGND_uq2 1851.3
R2532 VGND_uq0.n200 VGND_uq0.n162 3346.58
R2533 VGND_uq0.n200 VGND_uq0.n161 4875.58
R2534 VGND_uq0.n200 VGND_uq2 220.327
R2535 VGND_uq0.n10 VGND_uq0.n162 69362.2
R2536 VGND_uq0.n10 VGND_uq0.n161 101053
R2537 VGND_uq0.n10 VGND_uq2 4566.56
R2538 VGND_uq0.n88 VGND_uq0.n173 3466.36
R2539 VGND_uq0.n88 VGND_uq0.n174 10030.8
R2540 VGND_uq0.n88 VGND_uq0.n175 1873.01
R2541 VGND_uq0.n173 VGND_uq0.n87 38799.3
R2542 VGND_uq0.n174 VGND_uq0.n87 112276
R2543 VGND_uq0.n175 VGND_uq0.n87 20964.8
C0 RARR/R2_4 RARR/R2_3 0.13182f
C1 halfN/dff5/D VDPWR 0.01225f
C2 uio_out[7] VDPWR 0.20486f
C3 VDPWR ua[1] 0.12743f
C4 VDPWR halfP/dff5/D 0.01225f
C5 VDPWR clk 0.06299f
C6 VDPWR ua[0] 0.12743f
C7 uio_out[0] uo_out[7] 0.51433f
C8 uio_out[0] clk 0.02014f
C9 halfN/mon/A halfP/mon/A 0.10005f
C10 uio_out[1] uo_out[6] 0.01771f
C11 ua[1] RARR/R1_1 0.03259f
C12 ua[1] ua[0] 5.29542f
C13 ua[1] RARR/R1_3 0.01074f
C14 RARR/R1_1 RARR/R1_3 0.0619f
C15 uo_out[5] clk 0.09007f
C16 uo_out[1] clk 0.10706f
C17 uo_out[4] clk 0.09291f
C18 halfP/dff5/a_1062_300# clk 0.01146f
C19 uo_out[0] clk 0.11135f
C20 uo_out[0] uio_in[7] 0.03102f
C21 uo_out[3] clk 0.08984f
C22 uo_out[7] clk 0.10056f
C23 clk uo_out[6] 0.09053f
C24 clk uo_out[2] 0.09242f
C25 clk rst_n 0.0316f
C26 clk ena 0.03102f
C27 ua[0] RARR/R1_3 0.02298f
C28 ua[0] VDPWR_uq0 4.35835f
C29 VGND_uq1 VDPWR_uq1 14.8106f
C30 VGND VDPWR_uq0 14.8106f
C31 uio_in[7] uio_in[6] 0.03102f
C32 uio_in[6] uio_in[5] 0.03102f
C33 uio_in[5] uio_in[4] 0.03102f
C34 uio_in[4] uio_in[3] 0.03102f
C35 uio_in[3] uio_in[2] 0.03102f
C36 uio_in[2] uio_in[1] 0.03102f
C37 uio_in[1] uio_in[0] 0.03102f
C38 uio_in[0] ui_in[7] 0.03102f
C39 ui_in[7] ui_in[6] 0.03102f
C40 ui_in[6] ui_in[5] 0.03102f
C41 ui_in[5] ui_in[4] 0.03102f
C42 ui_in[4] ui_in[3] 0.03102f
C43 ui_in[3] ui_in[2] 0.03102f
C44 ui_in[2] ui_in[1] 0.03102f
C45 ui_in[1] ui_in[0] 0.03102f
C46 ui_in[0] rst_n 0.03102f
C47 VDPWR_uq0 VGND_uq2 7.16258f
C48 ua[2] VGND_uq2 0.14696f
C49 ua[3] VGND_uq2 0.14696f
C50 ua[4] VGND_uq2 0.14696f
C51 ua[5] VGND_uq2 0.14696f
C52 ua[6] VGND_uq2 0.14696f
C53 ua[7] VGND_uq2 0.14696f
C54 VDPWR_uq1 VGND_uq2 11.6128f
C55 ena VGND_uq2 0.07038f
C56 rst_n VGND_uq2 0.0426f
C57 ui_in[0] VGND_uq2 0.0426f
C58 ui_in[1] VGND_uq2 0.0426f
C59 ui_in[2] VGND_uq2 0.0426f
C60 ui_in[3] VGND_uq2 0.0426f
C61 ui_in[4] VGND_uq2 0.0426f
C62 ui_in[5] VGND_uq2 0.0426f
C63 ui_in[6] VGND_uq2 0.0426f
C64 ui_in[7] VGND_uq2 0.0426f
C65 uio_in[0] VGND_uq2 0.0426f
C66 uio_in[1] VGND_uq2 0.0426f
C67 uio_in[2] VGND_uq2 0.0426f
C68 uio_in[3] VGND_uq2 0.0426f
C69 uio_in[4] VGND_uq2 0.0426f
C70 uio_in[5] VGND_uq2 0.0426f
C71 uio_in[6] VGND_uq2 0.04281f
C72 uio_in[7] VGND_uq2 0.04281f
C73 VGND VGND_uq2 12.01756f
C74 VGND_uq1 VGND_uq2 11.8264f
C75 VGND_uq0.n2 VGND_uq2 0.022f
C76 VGND_uq0.n3 VGND_uq2 0.03785f
C77 VGND_uq0.n4 VGND_uq2 0.04668f
C78 VGND_uq0.n8 VGND_uq2 1.05577f
C79 VGND_uq0.n21 VGND_uq2 0.02918f
C80 VGND_uq0.n24 VGND_uq2 0.02753f
C81 VGND_uq0.n41 VGND_uq2 0.02103f
C82 VGND_uq0.n45 VGND_uq2 0.01857f
C83 VGND_uq0.n47 VGND_uq2 0.01516f
C84 VGND_uq0.n78 VGND_uq2 0.03952f
C85 VGND_uq0.n87 VGND_uq2 0.19118f
C86 VGND_uq0.n88 VGND_uq2 2.2405f
C87 VGND_uq0.n89 VGND_uq2 0.3271f
C88 VGND_uq0.n90 VGND_uq2 0.12624f
C89 VGND_uq0.n92 VGND_uq2 0.15731f
C90 VGND_uq0.n95 VGND_uq2 0.14383f
C91 VGND_uq0.n96 VGND_uq2 0.13216f
C92 VGND_uq0.n98 VGND_uq2 0.15181f
C93 VGND_uq0.n102 VGND_uq2 0.10081f
C94 VGND_uq0.n104 VGND_uq2 0.13992f
C95 VGND_uq0.n105 VGND_uq2 0.12612f
C96 VGND_uq0.n109 VGND_uq2 0.10835f
C97 VGND_uq0.n115 VGND_uq2 0.02181f
C98 VGND_uq0.n118 VGND_uq2 0.02104f
C99 VGND_uq0.n124 VGND_uq2 0.01548f
C100 VGND_uq0.n125 VGND_uq2 0.01188f
C101 VGND_uq0.n126 VGND_uq2 0.01516f
C102 VGND_uq0.n131 VGND_uq2 0.01298f
C103 VGND_uq0.n161 VGND_uq2 0.01697f
C104 VGND_uq0.n162 VGND_uq2 0.0215f
C105 VGND_uq0.n163 VGND_uq2 0.01597f
C106 VGND_uq0.n171 VGND_uq2 0.01129f
C107 VGND_uq0.n173 VGND_uq2 0.36933f
C108 VGND_uq0.n174 VGND_uq2 0.10288f
C109 VGND_uq0.n175 VGND_uq2 0.27443f
C110 VGND_uq0.n179 VGND_uq2 0.02102f
C111 VGND_uq0.n182 VGND_uq2 0.02771f
C112 VGND_uq0.n185 VGND_uq2 0.14901f
C113 VGND_uq0.n187 VGND_uq2 0.09915f
C114 VGND_uq0.n188 VGND_uq2 0.12041f
C115 VGND_uq0.n191 VGND_uq2 0.14431f
C116 VGND_uq0.n192 VGND_uq2 0.13461f
C117 VGND_uq0.n194 VGND_uq2 0.14923f
C118 VGND_uq0.n197 VGND_uq2 0.14484f
C119 VGND_uq0.n198 VGND_uq2 0.13634f
C120 VGND_uq0.n200 VGND_uq2 0.24771f
C121 VGND_uq0.n201 VGND_uq2 0.01459f
C122 VGND_uq2.n1 VGND_uq2 0.04828f
C123 VGND_uq2.n3 VGND_uq2 0.03834f
C124 VGND_uq2.n4 VGND_uq2 0.05639f
C125 VGND_uq2.n7 VGND_uq2 0.80264f
C126 VGND_uq2.n8 VGND_uq2 0.05508f
C127 VGND_uq2.n14 VGND_uq2 0.02081f
C128 VGND_uq2.n24 VGND_uq2 0.15771f
C129 VGND_uq2.n26 VGND_uq2 0.01685f
C130 VGND_uq2.n30 VGND_uq2 0.01568f
C131 VGND_uq2.n31 VGND_uq2 0.02398f
C132 VGND_uq2.n49 VGND_uq2 0.03663f
C133 VGND_uq2.n56 VGND_uq2 0.0385f
C134 VGND_uq2.n57 VGND_uq2 0.07018f
C135 VGND_uq2.n58 VGND_uq2 0.01173f
C136 VGND_uq2.n59 VGND_uq2 7.76404f
C137 VGND_uq2.n76 VGND_uq2 0.16474f
C138 VGND_uq2.n77 VGND_uq2 0.88594f
C139 VGND_uq2.n83 VGND_uq2 0.02696f
C140 VGND_uq2.n87 VGND_uq2 0.02642f
C141 VGND_uq2.n88 VGND_uq2 0.03235f
C142 VGND_uq2.n92 VGND_uq2 0.0447f
C143 VGND_uq2.n95 VGND_uq2 0.02262f
C144 VGND_uq2.n130 VGND_uq2 0.25411f
C145 VGND_uq2.n133 VGND_uq2 0.04269f
C146 VGND_uq2.n134 VGND_uq2 0.04067f
C147 VGND_uq2.n135 VGND_uq2 0.0468f
C148 VGND_uq2.n136 VGND_uq2 0.40541f
C149 VGND_uq2.n137 VGND_uq2 0.02428f
C150 VGND_uq2.n138 VGND_uq2 0.24409f
C151 VGND_uq2.n142 VGND_uq2 0.13265f
C152 VGND_uq2.n144 VGND_uq2 0.2117f
C153 VGND_uq2.n147 VGND_uq2 0.25334f
C154 VGND_uq2.n148 VGND_uq2 0.27446f
C155 VGND_uq2.n149 VGND_uq2 0.19268f
C156 VGND_uq2.n151 VGND_uq2 0.17276f
C157 VGND_uq2.n154 VGND_uq2 0.25976f
C158 VGND_uq2.n155 VGND_uq2 0.05085f
C159 VGND_uq2.n158 VGND_uq2 0.02697f
C160 VGND_uq2.n162 VGND_uq2 0.03662f
C161 RARR/R1_3 VGND_uq2 0.52455f
C162 ua[0] VGND_uq2 20.1433f
C163 uo_out[2] VGND_uq2 -0.3096f
C164 halfP/dff1/D VGND_uq2 -0.06255f
C165 uo_out[6] VGND_uq2 -0.35719f
C166 halfP/mon/A VGND_uq2 -0.12176f
C167 clk VGND_uq2 0.94441f
C168 uo_out[7] VGND_uq2 -0.76708f
C169 uo_out[3] VGND_uq2 -0.32033f
C170 halfP/dff6/D VGND_uq2 -0.18003f
C171 uo_out[0] VGND_uq2 -0.21854f
C172 halfP/dff5/D VGND_uq2 -0.20427f
C173 uo_out[4] VGND_uq2 -0.23407f
C174 halfP/dff4/D VGND_uq2 -0.24439f
C175 uo_out[1] VGND_uq2 -0.23649f
C176 halfP/dff3/D VGND_uq2 -0.15526f
C177 uo_out[5] VGND_uq2 -0.27718f
C178 halfP/dff2/D VGND_uq2 -0.15823f
C179 RARR/R1_1 VGND_uq2 0.45434f
C180 ua[1] VGND_uq2 22.6981f
C181 uio_out[5] VGND_uq2 -0.30274f
C182 halfN/dff1/D VGND_uq2 -0.07246f
C183 uio_out[1] VGND_uq2 -0.35033f
C184 halfN/mon/A VGND_uq2 -0.13169f
C185 uio_out[0] VGND_uq2 -0.76305f
C186 uio_out[4] VGND_uq2 -0.31347f
C187 halfN/dff6/D VGND_uq2 -0.18994f
C188 VDPWR VGND_uq2 22.43512f
C189 uio_out[7] VGND_uq2 -0.33559f
C190 halfN/dff5/D VGND_uq2 -0.21419f
C191 uio_out[3] VGND_uq2 -0.22721f
C192 halfN/dff4/D VGND_uq2 -0.2543f
C193 uio_out[6] VGND_uq2 -0.21062f
C194 halfN/dff3/D VGND_uq2 -0.16517f
C195 uio_out[2] VGND_uq2 -0.27031f
C196 halfN/dff2/D VGND_uq2 -0.16814f
C197 RARR/R2_3 VGND_uq2 0.04027f
C198 RARR/R2_4 VGND_uq2 0.23639f
.ends
