* NGSPICE file created from tt_um_arcadia1_vco_adc.ext - technology: sky130A

.subckt sky130_fd_pr__res_xhigh_po_0p35_4MFQX6 R1_4 R1_3 R1_2 R1_1 R1_0 B R2_7 R2_6
+ R2_5 R2_4 R2_3 R2_2 R2_1 R2_0 R1_7 R1_6 R1_5
X0 R1_0 R2_0 B sky130_fd_pr__res_xhigh_po_0p35 l=4.38
X1 R1_6 R2_6 B sky130_fd_pr__res_xhigh_po_0p35 l=4.38
X2 R1_7 R2_7 B sky130_fd_pr__res_xhigh_po_0p35 l=4.38
X3 R1_5 R2_5 B sky130_fd_pr__res_xhigh_po_0p35 l=4.38
X4 R1_2 R2_2 B sky130_fd_pr__res_xhigh_po_0p35 l=4.38
X5 R1_4 R2_4 B sky130_fd_pr__res_xhigh_po_0p35 l=4.38
X6 R1_1 R2_1 B sky130_fd_pr__res_xhigh_po_0p35 l=4.38
X7 R1_3 R2_3 B sky130_fd_pr__res_xhigh_po_0p35 l=4.38
C0 R2_3 R2_2 0.29626f
C1 R2_6 R2_7 0.29626f
C2 R1_6 R1_5 0.29626f
C3 R2_3 R2_4 0.29626f
C4 R2_6 R2_5 0.29626f
C5 R1_4 R1_5 0.29626f
C6 R1_4 R1_3 0.29626f
C7 R1_2 R1_1 0.29626f
C8 R1_2 R1_3 0.29626f
C9 R1_1 R1_0 0.29626f
C10 R1_7 R1_6 0.29626f
C11 R2_5 R2_4 0.29626f
C12 R2_0 R2_1 0.29626f
C13 R2_2 R2_1 0.29626f
C14 R2_7 B 0.39525f
C15 R1_7 B 0.39525f
C16 R2_6 B 0.17336f
C17 R1_6 B 0.17336f
C18 R2_5 B 0.17325f
C19 R1_5 B 0.17325f
C20 R2_4 B 0.17336f
C21 R1_4 B 0.17336f
C22 R2_3 B 0.17336f
C23 R1_3 B 0.17336f
C24 R2_2 B 0.17325f
C25 R1_2 B 0.17325f
C26 R2_1 B 0.17336f
C27 R1_1 B 0.17336f
C28 R2_0 B 0.39525f
C29 R1_0 B 0.39525f
.ends

.subckt sky130_fd_pr__res_xhigh_po_0p35_9LMN9P R1_4 R1_3 R1_2 R1_1 R1_0 B R2_5 R2_4
+ R2_3 R2_2 R2_1 R2_0 R1_5
X0 R1_0 R2_0 B sky130_fd_pr__res_xhigh_po_0p35 l=20
X1 R1_1 R2_1 B sky130_fd_pr__res_xhigh_po_0p35 l=20
X2 R1_3 R2_3 B sky130_fd_pr__res_xhigh_po_0p35 l=20
X3 R1_4 R2_4 B sky130_fd_pr__res_xhigh_po_0p35 l=20
X4 R1_2 R2_2 B sky130_fd_pr__res_xhigh_po_0p35 l=20
X5 R1_5 R2_5 B sky130_fd_pr__res_xhigh_po_0p35 l=20
C0 R1_1 R1_2 0.29626f
C1 R2_0 R2_1 0.29626f
C2 R1_5 R1_4 0.29626f
C3 R2_2 R2_3 0.29626f
C4 R1_3 R1_2 0.29626f
C5 R2_5 R2_4 0.29626f
C6 R2_4 R2_3 0.29626f
C7 R1_3 R1_4 0.29626f
C8 R2_2 R2_1 0.29626f
C9 R1_1 R1_0 0.29626f
C10 R2_5 B 0.40095f
C11 R1_5 B 0.40095f
C12 R2_4 B 0.17894f
C13 R1_4 B 0.17894f
C14 R2_3 B 0.17883f
C15 R1_3 B 0.17883f
C16 R2_2 B 0.17883f
C17 R1_2 B 0.17883f
C18 R2_1 B 0.17894f
C19 R1_1 B 0.17894f
C20 R2_0 B 0.40095f
C21 R1_0 B 0.40095f
.ends

.subckt sky130_fd_pr__res_xhigh_po_0p35_V6BCNG R1_3 R1_2 R1_1 R1_0 B R2_3 R2_2 R2_1
+ R2_0
X0 R1_1 R2_1 B sky130_fd_pr__res_xhigh_po_0p35 l=3.25
X1 R1_3 R2_3 B sky130_fd_pr__res_xhigh_po_0p35 l=3.25
X2 R1_0 R2_0 B sky130_fd_pr__res_xhigh_po_0p35 l=3.25
X3 R1_2 R2_2 B sky130_fd_pr__res_xhigh_po_0p35 l=3.25
C0 R1_1 R1_0 0.29626f
C1 R2_1 R2_0 0.29626f
C2 R1_3 R1_2 0.29626f
C3 R2_3 R2_2 0.29626f
C4 R2_1 R2_2 0.29626f
C5 R1_1 R1_2 0.29626f
C6 R2_3 B 0.39412f
C7 R1_3 B 0.39412f
C8 R2_2 B 0.17161f
C9 R1_2 B 0.17161f
C10 R2_1 B 0.17161f
C11 R1_1 B 0.17161f
C12 R2_0 B 0.39412f
C13 R1_0 B 0.39412f
.ends

.subckt sky130_fd_sc_hd__xor2_1 VNB VPB VPWR VGND A X B a_285_297# a_35_297#
X0 X a_35_297# a_285_297# VPB sky130_fd_pr__pfet_01v8_hvt ad=0.3 pd=2.6 as=0.26 ps=2.52 w=1 l=0.15
X1 X B a_285_47# VNB sky130_fd_pr__nfet_01v8 ad=0.25025 pd=1.42 as=0.08775 ps=0.92 w=0.65 l=0.15
X2 a_35_297# B VGND VNB sky130_fd_pr__nfet_01v8 ad=0.08775 pd=0.92 as=0.169 ps=1.82 w=0.65 l=0.15
X3 a_117_297# B a_35_297# VPB sky130_fd_pr__pfet_01v8_hvt ad=0.135 pd=1.27 as=0.26 ps=2.52 w=1 l=0.15
X4 VPWR B a_285_297# VPB sky130_fd_pr__pfet_01v8_hvt ad=0.26 pd=2.52 as=0.135 ps=1.27 w=1 l=0.15
X5 VGND A a_35_297# VNB sky130_fd_pr__nfet_01v8 ad=0.08775 pd=0.92 as=0.08775 ps=0.92 w=0.65 l=0.15
X6 VGND a_35_297# X VNB sky130_fd_pr__nfet_01v8 ad=0.208 pd=1.94 as=0.25025 ps=1.42 w=0.65 l=0.15
X7 a_285_297# A VPWR VPB sky130_fd_pr__pfet_01v8_hvt ad=0.135 pd=1.27 as=0.135 ps=1.27 w=1 l=0.15
X8 VPWR A a_117_297# VPB sky130_fd_pr__pfet_01v8_hvt ad=0.135 pd=1.27 as=0.135 ps=1.27 w=1 l=0.15
X9 a_285_47# A VGND VNB sky130_fd_pr__nfet_01v8 ad=0.08775 pd=0.92 as=0.08775 ps=0.92 w=0.65 l=0.15
C0 VPWR a_285_297# 0.24631f
C1 a_35_297# a_285_297# 0.02504f
C2 A VPB 0.05101f
C3 a_35_297# VPWR 0.09604f
C4 A VPWR 0.03484f
C5 A a_35_297# 0.06334f
C6 VGND X 0.1729f
C7 B X 0.01488f
C8 B VPB 0.06969f
C9 B a_285_297# 0.05532f
C10 VGND VPWR 0.06426f
C11 a_35_297# VGND 0.17666f
C12 B VPWR 0.07031f
C13 a_35_297# B 0.203f
C14 A VGND 0.03254f
C15 A B 0.22134f
C16 X VPB 0.01541f
C17 X a_285_297# 0.07125f
C18 VPB a_285_297# 0.01327f
C19 X VPWR 0.05365f
C20 VGND B 0.03045f
C21 a_35_297# X 0.166f
C22 VPB VPWR 0.06891f
C23 a_35_297# VPB 0.06993f
C24 VGND VNB 0.43488f
C25 X VNB 0.06491f
C26 VPWR VNB 0.33278f
C27 A VNB 0.16672f
C28 B VNB 0.21337f
C29 VPB VNB 0.69336f
C30 a_35_297# VNB 0.25457f
.ends

.subckt sky130_fd_sc_hd__dfxtp_4 VGND VPWR VNB VPB Q D CLK a_891_413# a_193_47# a_381_47#
+ a_1062_300# a_475_413# a_634_183# a_27_47#
X0 Q a_1062_300# VPWR VPB sky130_fd_pr__pfet_01v8_hvt ad=0.135 pd=1.27 as=0.1425 ps=1.285 w=1 l=0.15
X1 a_1020_47# a_27_47# a_891_413# VNB sky130_fd_pr__special_nfet_01v8 ad=0.066 pd=0.745 as=0.0657 ps=0.725 w=0.36 l=0.15
X2 a_572_47# a_193_47# a_475_413# VNB sky130_fd_pr__special_nfet_01v8 ad=0.0687 pd=0.76 as=0.0594 ps=0.69 w=0.36 l=0.15
X3 VPWR a_1062_300# a_975_413# VPB sky130_fd_pr__pfet_01v8_hvt ad=0.1218 pd=1.42 as=0.09135 ps=0.855 w=0.42 l=0.15
X4 a_634_183# a_475_413# VGND VNB sky130_fd_pr__nfet_01v8 ad=0.0989 pd=0.995 as=0.1493 ps=1.22 w=0.64 l=0.15
X5 VPWR CLK a_27_47# VPB sky130_fd_pr__pfet_01v8_hvt ad=0.0864 pd=0.91 as=0.1664 ps=1.8 w=0.64 l=0.15
X6 a_381_47# D VPWR VPB sky130_fd_pr__pfet_01v8_hvt ad=0.0672 pd=0.74 as=0.1092 ps=1.36 w=0.42 l=0.15
X7 a_475_413# a_27_47# a_381_47# VNB sky130_fd_pr__special_nfet_01v8 ad=0.0594 pd=0.69 as=0.066 ps=0.745 w=0.36 l=0.15
X8 VGND a_1062_300# a_1020_47# VNB sky130_fd_pr__nfet_01v8 ad=0.1197 pd=1.41 as=0.066 ps=0.745 w=0.42 l=0.15
X9 VPWR a_634_183# a_568_413# VPB sky130_fd_pr__pfet_01v8_hvt ad=0.17887 pd=1.26 as=0.0693 ps=0.75 w=0.42 l=0.15
X10 Q a_1062_300# VGND VNB sky130_fd_pr__nfet_01v8 ad=0.08775 pd=0.92 as=0.09262 ps=0.935 w=0.65 l=0.15
X11 a_568_413# a_27_47# a_475_413# VPB sky130_fd_pr__pfet_01v8_hvt ad=0.0693 pd=0.75 as=0.06615 ps=0.735 w=0.42 l=0.15
X12 a_634_183# a_475_413# VPWR VPB sky130_fd_pr__pfet_01v8_hvt ad=0.1095 pd=1.075 as=0.17887 ps=1.26 w=0.75 l=0.15
X13 a_975_413# a_193_47# a_891_413# VPB sky130_fd_pr__pfet_01v8_hvt ad=0.09135 pd=0.855 as=0.0567 ps=0.69 w=0.42 l=0.15
X14 a_193_47# a_27_47# VGND VNB sky130_fd_pr__nfet_01v8 ad=0.1092 pd=1.36 as=0.0567 ps=0.69 w=0.42 l=0.15
X15 a_891_413# a_27_47# a_634_183# VPB sky130_fd_pr__pfet_01v8_hvt ad=0.0567 pd=0.69 as=0.1095 ps=1.075 w=0.42 l=0.15
X16 Q a_1062_300# VGND VNB sky130_fd_pr__nfet_01v8 ad=0.08775 pd=0.92 as=0.10563 ps=0.975 w=0.65 l=0.15
X17 VGND a_891_413# a_1062_300# VNB sky130_fd_pr__nfet_01v8 ad=0.10563 pd=0.975 as=0.169 ps=1.82 w=0.65 l=0.15
X18 VPWR a_1062_300# Q VPB sky130_fd_pr__pfet_01v8_hvt ad=0.1425 pd=1.285 as=0.135 ps=1.27 w=1 l=0.15
X19 VGND a_1062_300# Q VNB sky130_fd_pr__nfet_01v8 ad=0.18525 pd=1.87 as=0.08775 ps=0.92 w=0.65 l=0.15
X20 Q a_1062_300# VPWR VPB sky130_fd_pr__pfet_01v8_hvt ad=0.135 pd=1.27 as=0.1625 ps=1.325 w=1 l=0.15
X21 a_193_47# a_27_47# VPWR VPB sky130_fd_pr__pfet_01v8_hvt ad=0.1664 pd=1.8 as=0.0864 ps=0.91 w=0.64 l=0.15
X22 VGND a_1062_300# Q VNB sky130_fd_pr__nfet_01v8 ad=0.09262 pd=0.935 as=0.08775 ps=0.92 w=0.65 l=0.15
X23 a_381_47# D VGND VNB sky130_fd_pr__nfet_01v8 ad=0.066 pd=0.745 as=0.1092 ps=1.36 w=0.42 l=0.15
X24 VPWR a_891_413# a_1062_300# VPB sky130_fd_pr__pfet_01v8_hvt ad=0.1625 pd=1.325 as=0.28 ps=2.56 w=1 l=0.15
X25 a_475_413# a_193_47# a_381_47# VPB sky130_fd_pr__pfet_01v8_hvt ad=0.06615 pd=0.735 as=0.0672 ps=0.74 w=0.42 l=0.15
X26 a_891_413# a_193_47# a_634_183# VNB sky130_fd_pr__special_nfet_01v8 ad=0.0657 pd=0.725 as=0.0989 ps=0.995 w=0.36 l=0.15
X27 VGND a_634_183# a_572_47# VNB sky130_fd_pr__nfet_01v8 ad=0.1493 pd=1.22 as=0.0687 ps=0.76 w=0.42 l=0.15
X28 VGND CLK a_27_47# VNB sky130_fd_pr__nfet_01v8 ad=0.0567 pd=0.69 as=0.1092 ps=1.36 w=0.42 l=0.15
X29 VPWR a_1062_300# Q VPB sky130_fd_pr__pfet_01v8_hvt ad=0.28 pd=2.56 as=0.135 ps=1.27 w=1 l=0.15
C0 VPB a_193_47# 0.14138f
C1 a_381_47# VPWR 0.05338f
C2 a_27_47# VPWR 0.3831f
C3 VGND VPWR 0.10063f
C4 VPB a_475_413# 0.07594f
C5 a_1062_300# VPWR 0.22605f
C6 VPB VPWR 0.19856f
C7 a_381_47# a_27_47# 0.03397f
C8 a_381_47# VGND 0.04483f
C9 VGND a_27_47# 0.12468f
C10 a_634_183# a_891_413# 0.03548f
C11 a_27_47# a_1062_300# 0.04869f
C12 VGND a_1062_300# 0.19483f
C13 VPB a_381_47# 0.01358f
C14 VPB a_27_47# 0.27543f
C15 VPB VGND 0.01466f
C16 a_634_183# a_193_47# 0.13099f
C17 VPB a_1062_300# 0.24732f
C18 D a_193_47# 0.10396f
C19 a_634_183# a_475_413# 0.24864f
C20 a_634_183# VPWR 0.10209f
C21 D VPWR 0.02726f
C22 Q VPWR 0.33578f
C23 VPWR CLK 0.01941f
C24 a_634_183# a_27_47# 0.16612f
C25 VGND a_634_183# 0.12391f
C26 a_381_47# D 0.07679f
C27 D a_27_47# 0.09699f
C28 VGND D 0.0264f
C29 a_193_47# a_891_413# 0.13928f
C30 VGND Q 0.24206f
C31 a_27_47# CLK 0.21376f
C32 VGND CLK 0.01946f
C33 a_1062_300# Q 0.38792f
C34 VPB a_634_183# 0.07362f
C35 VPB D 0.09609f
C36 VPB Q 0.01336f
C37 VPWR a_891_413# 0.11394f
C38 VPB CLK 0.07006f
C39 a_193_47# a_475_413# 0.15754f
C40 a_193_47# VPWR 0.10663f
C41 a_27_47# a_891_413# 0.03777f
C42 VGND a_891_413# 0.11673f
C43 VPWR a_475_413# 0.16822f
C44 a_1062_300# a_891_413# 0.28549f
C45 VPB a_891_413# 0.06876f
C46 a_381_47# a_193_47# 0.16187f
C47 a_193_47# a_27_47# 0.72386f
C48 VGND a_193_47# 0.30543f
C49 a_193_47# a_1062_300# 0.03024f
C50 a_381_47# a_475_413# 0.03564f
C51 a_27_47# a_475_413# 0.17844f
C52 VGND a_475_413# 0.09216f
C53 Q VNB 0.0608f
C54 VGND VNB 0.98893f
C55 VPWR VNB 0.82311f
C56 D VNB 0.12973f
C57 CLK VNB 0.19598f
C58 VPB VNB 1.75651f
C59 a_381_47# VNB 0.0164f
C60 a_891_413# VNB 0.16089f
C61 a_1062_300# VNB 0.52966f
C62 a_475_413# VNB 0.13718f
C63 a_634_183# VNB 0.15021f
C64 a_193_47# VNB 0.27118f
C65 a_27_47# VNB 0.4683f
.ends

.subckt sky130_fd_pr__res_xhigh_po_0p35_Y3K97R R1_1 R1_0 B R2_1 R2_0
X0 R1_1 R2_1 B sky130_fd_pr__res_xhigh_po_0p35 l=4.3
X1 R1_0 R2_0 B sky130_fd_pr__res_xhigh_po_0p35 l=4.3
C0 R1_0 R1_1 0.29626f
C1 R2_0 R2_1 0.29626f
C2 R2_1 B 0.39561f
C3 R1_1 B 0.39561f
C4 R2_0 B 0.39561f
C5 R1_0 B 0.39561f
.ends

.subckt sky130_fd_sc_hd__buf_4 VPWR VGND X A VPB VNB a_27_47#
X0 VPWR a_27_47# X VPB sky130_fd_pr__pfet_01v8_hvt ad=0.26 pd=2.52 as=0.135 ps=1.27 w=1 l=0.15
X1 X a_27_47# VPWR VPB sky130_fd_pr__pfet_01v8_hvt ad=0.135 pd=1.27 as=0.135 ps=1.27 w=1 l=0.15
X2 VPWR a_27_47# X VPB sky130_fd_pr__pfet_01v8_hvt ad=0.135 pd=1.27 as=0.135 ps=1.27 w=1 l=0.15
X3 X a_27_47# VPWR VPB sky130_fd_pr__pfet_01v8_hvt ad=0.135 pd=1.27 as=0.135 ps=1.27 w=1 l=0.15
X4 X a_27_47# VGND VNB sky130_fd_pr__nfet_01v8 ad=0.08775 pd=0.92 as=0.08775 ps=0.92 w=0.65 l=0.15
X5 X a_27_47# VGND VNB sky130_fd_pr__nfet_01v8 ad=0.08775 pd=0.92 as=0.08775 ps=0.92 w=0.65 l=0.15
X6 VGND a_27_47# X VNB sky130_fd_pr__nfet_01v8 ad=0.08775 pd=0.92 as=0.08775 ps=0.92 w=0.65 l=0.15
X7 VGND a_27_47# X VNB sky130_fd_pr__nfet_01v8 ad=0.169 pd=1.82 as=0.08775 ps=0.92 w=0.65 l=0.15
X8 VPWR A a_27_47# VPB sky130_fd_pr__pfet_01v8_hvt ad=0.135 pd=1.27 as=0.26 ps=2.52 w=1 l=0.15
X9 VGND A a_27_47# VNB sky130_fd_pr__nfet_01v8 ad=0.08775 pd=0.92 as=0.169 ps=1.82 w=0.65 l=0.15
C0 X VPWR 0.33254f
C1 A VPWR 0.01601f
C2 a_27_47# VPWR 0.21812f
C3 VGND VPWR 0.07203f
C4 VPWR VPB 0.07107f
C5 X a_27_47# 0.20651f
C6 X VGND 0.22989f
C7 A a_27_47# 0.17018f
C8 A VGND 0.01937f
C9 a_27_47# VGND 0.16264f
C10 A VPB 0.03609f
C11 a_27_47# VPB 0.13215f
C12 VGND VNB 0.37777f
C13 X VNB 0.03903f
C14 VPWR VNB 0.32508f
C15 A VNB 0.13997f
C16 VPB VNB 0.60476f
C17 a_27_47# VNB 0.46146f
.ends

.subckt sky130_fd_pr__cap_mim_m3_1_4SMZ5E C1 C2 VSUBS
X0 C1 C2 sky130_fd_pr__cap_mim_m3_1 l=25 w=24
C0 C2 C1 53.1086f
C1 C1 VSUBS 2.52332f
C2 C2 VSUBS 13.4166f
.ends

.subckt sky130_fd_sc_hd__dfxtp_1 Q CLK D VPB VNB VPWR VGND a_891_413# a_466_413# a_1059_315#
+ a_193_47# a_634_159# a_381_47# a_27_47#
X0 Q a_1059_315# VGND VNB sky130_fd_pr__nfet_01v8 ad=0.169 pd=1.82 as=0.08775 ps=0.92 w=0.65 l=0.15
X1 a_891_413# a_193_47# a_634_159# VNB sky130_fd_pr__special_nfet_01v8 ad=0.0684 pd=0.74 as=0.0989 ps=0.995 w=0.36 l=0.15
X2 a_561_413# a_27_47# a_466_413# VPB sky130_fd_pr__pfet_01v8_hvt ad=0.07665 pd=0.785 as=0.06825 ps=0.745 w=0.42 l=0.15
X3 VPWR CLK a_27_47# VPB sky130_fd_pr__pfet_01v8_hvt ad=0.0864 pd=0.91 as=0.1664 ps=1.8 w=0.64 l=0.15
X4 Q a_1059_315# VPWR VPB sky130_fd_pr__pfet_01v8_hvt ad=0.26 pd=2.52 as=0.135 ps=1.27 w=1 l=0.15
X5 a_381_47# D VPWR VPB sky130_fd_pr__pfet_01v8_hvt ad=0.05775 pd=0.695 as=0.1092 ps=1.36 w=0.42 l=0.15
X6 VGND a_634_159# a_592_47# VNB sky130_fd_pr__nfet_01v8 ad=0.12095 pd=1.085 as=0.0696 ps=0.765 w=0.42 l=0.15
X7 VPWR a_891_413# a_1059_315# VPB sky130_fd_pr__pfet_01v8_hvt ad=0.135 pd=1.27 as=0.27 ps=2.54 w=1 l=0.15
X8 a_466_413# a_193_47# a_381_47# VPB sky130_fd_pr__pfet_01v8_hvt ad=0.06825 pd=0.745 as=0.05775 ps=0.695 w=0.42 l=0.15
X9 VPWR a_634_159# a_561_413# VPB sky130_fd_pr__pfet_01v8_hvt ad=0.17887 pd=1.26 as=0.07665 ps=0.785 w=0.42 l=0.15
X10 a_634_159# a_466_413# VGND VNB sky130_fd_pr__nfet_01v8 ad=0.0989 pd=0.995 as=0.12095 ps=1.085 w=0.64 l=0.15
X11 a_634_159# a_466_413# VPWR VPB sky130_fd_pr__pfet_01v8_hvt ad=0.1095 pd=1.075 as=0.17887 ps=1.26 w=0.75 l=0.15
X12 a_975_413# a_193_47# a_891_413# VPB sky130_fd_pr__pfet_01v8_hvt ad=0.0882 pd=0.84 as=0.0567 ps=0.69 w=0.42 l=0.15
X13 VGND a_1059_315# a_1017_47# VNB sky130_fd_pr__nfet_01v8 ad=0.1092 pd=1.36 as=0.066 ps=0.745 w=0.42 l=0.15
X14 a_193_47# a_27_47# VGND VNB sky130_fd_pr__nfet_01v8 ad=0.1092 pd=1.36 as=0.0567 ps=0.69 w=0.42 l=0.15
X15 a_891_413# a_27_47# a_634_159# VPB sky130_fd_pr__pfet_01v8_hvt ad=0.0567 pd=0.69 as=0.1095 ps=1.075 w=0.42 l=0.15
X16 a_592_47# a_193_47# a_466_413# VNB sky130_fd_pr__special_nfet_01v8 ad=0.0696 pd=0.765 as=0.0621 ps=0.705 w=0.36 l=0.15
X17 VPWR a_1059_315# a_975_413# VPB sky130_fd_pr__pfet_01v8_hvt ad=0.1113 pd=1.37 as=0.0882 ps=0.84 w=0.42 l=0.15
X18 a_1017_47# a_27_47# a_891_413# VNB sky130_fd_pr__special_nfet_01v8 ad=0.066 pd=0.745 as=0.0684 ps=0.74 w=0.36 l=0.15
X19 a_193_47# a_27_47# VPWR VPB sky130_fd_pr__pfet_01v8_hvt ad=0.1664 pd=1.8 as=0.0864 ps=0.91 w=0.64 l=0.15
X20 a_466_413# a_27_47# a_381_47# VNB sky130_fd_pr__special_nfet_01v8 ad=0.0621 pd=0.705 as=0.0813 ps=0.83 w=0.36 l=0.15
X21 VGND a_891_413# a_1059_315# VNB sky130_fd_pr__nfet_01v8 ad=0.08775 pd=0.92 as=0.169 ps=1.82 w=0.65 l=0.15
X22 a_381_47# D VGND VNB sky130_fd_pr__nfet_01v8 ad=0.0813 pd=0.83 as=0.1092 ps=1.36 w=0.42 l=0.15
X23 VGND CLK a_27_47# VNB sky130_fd_pr__nfet_01v8 ad=0.0567 pd=0.69 as=0.1092 ps=1.36 w=0.42 l=0.15
C0 VGND a_1059_315# 0.15512f
C1 a_891_413# a_1059_315# 0.31086f
C2 VPB a_1059_315# 0.15474f
C3 VGND CLK 0.01946f
C4 a_193_47# a_1059_315# 0.03405f
C5 CLK VPB 0.07006f
C6 a_891_413# VGND 0.13154f
C7 VGND VPB 0.01223f
C8 a_891_413# VPB 0.06977f
C9 a_193_47# VGND 0.2001f
C10 a_193_47# a_891_413# 0.19685f
C11 VPWR Q 0.11093f
C12 a_193_47# VPB 0.17613f
C13 VPWR a_1059_315# 0.23245f
C14 a_27_47# a_1059_315# 0.04875f
C15 D VGND 0.03899f
C16 VPWR CLK 0.01941f
C17 a_27_47# CLK 0.21384f
C18 D VPB 0.09633f
C19 VPWR VGND 0.06389f
C20 a_891_413# VPWR 0.11532f
C21 a_466_413# VGND 0.0888f
C22 a_193_47# D 0.17578f
C23 a_27_47# VGND 0.13669f
C24 a_891_413# a_27_47# 0.03224f
C25 VGND a_381_47# 0.05222f
C26 VPWR VPB 0.16818f
C27 VGND a_634_159# 0.12488f
C28 a_891_413# a_634_159# 0.03684f
C29 a_466_413# VPB 0.07446f
C30 a_27_47# VPB 0.24782f
C31 VPB a_381_47# 0.01414f
C32 VPB a_634_159# 0.07647f
C33 a_193_47# VPWR 0.11722f
C34 a_193_47# a_466_413# 0.08301f
C35 a_193_47# a_27_47# 0.97453f
C36 a_193_47# a_381_47# 0.10164f
C37 a_193_47# a_634_159# 0.12729f
C38 Q a_1059_315# 0.08125f
C39 D VPWR 0.02507f
C40 D a_27_47# 0.06586f
C41 D a_381_47# 0.11219f
C42 a_466_413# VPWR 0.17098f
C43 Q VGND 0.07661f
C44 VPWR a_27_47# 0.37986f
C45 a_466_413# a_27_47# 0.27314f
C46 VPWR a_381_47# 0.06128f
C47 a_466_413# a_381_47# 0.03733f
C48 VPWR a_634_159# 0.10213f
C49 a_27_47# a_381_47# 0.06222f
C50 a_466_413# a_634_159# 0.23992f
C51 Q VPB 0.01383f
C52 a_27_47# a_634_159# 0.14145f
C53 Q VNB 0.08826f
C54 VGND VNB 0.84362f
C55 VPWR VNB 0.68137f
C56 D VNB 0.14251f
C57 CLK VNB 0.19598f
C58 VPB VNB 1.49072f
C59 a_381_47# VNB 0.01537f
C60 a_891_413# VNB 0.16105f
C61 a_1059_315# VNB 0.24885f
C62 a_466_413# VNB 0.1332f
C63 a_634_159# VNB 0.14231f
C64 a_193_47# VNB 0.28426f
C65 a_27_47# VNB 0.44951f
.ends

.subckt sky130_fd_pr__res_xhigh_po_0p35_PZSUGD R1_4 R1_3 R1_2 R1_1 R1_0 B R2_5 R2_4
+ R2_3 R2_2 R2_1 R2_0 R1_5
X0 R1_4 R2_4 B sky130_fd_pr__res_xhigh_po_0p35 l=30.3
X1 R1_2 R2_2 B sky130_fd_pr__res_xhigh_po_0p35 l=30.3
X2 R1_5 R2_5 B sky130_fd_pr__res_xhigh_po_0p35 l=30.3
X3 R1_0 R2_0 B sky130_fd_pr__res_xhigh_po_0p35 l=30.3
X4 R1_1 R2_1 B sky130_fd_pr__res_xhigh_po_0p35 l=30.3
X5 R1_3 R2_3 B sky130_fd_pr__res_xhigh_po_0p35 l=30.3
C0 R1_1 R1_2 0.29626f
C1 R2_0 R2_1 0.29626f
C2 R1_5 R1_4 0.29626f
C3 R2_3 R2_4 0.29626f
C4 R2_5 R2_4 0.29626f
C5 R1_1 R1_0 0.29626f
C6 R2_1 R2_2 0.29626f
C7 R2_3 R2_2 0.29626f
C8 R1_3 R1_2 0.29626f
C9 R1_3 R1_4 0.29626f
C10 R2_5 B 0.40066f
C11 R1_5 B 0.40066f
C12 R2_4 B 0.17894f
C13 R1_4 B 0.17894f
C14 R2_3 B 0.17883f
C15 R1_3 B 0.17883f
C16 R2_2 B 0.17883f
C17 R1_2 B 0.17883f
C18 R2_1 B 0.17894f
C19 R1_1 B 0.17894f
C20 R2_0 B 0.40066f
C21 R1_0 B 0.40066f
.ends

.subckt vco_adc_half a_4654_26861# mon/A xq3/X CM1/C1 a_520_37976# a_1906_26237# w_440_39556#
+ a_586_39570# xq1/A a_3032_26237# xq6/A a_1800_26100# mon/X xq6/VPB xq4/X xq1/VPB
+ dq6/CLK xq5/VPB xq6/X CM1/C2 dff6/CLK dff5/D xq3/A xq4/A xq0/A xq5/A w_2846_27270#
+ xq5/X RIN/R2_0 dff4/D xq2/A RIN/B xq3/VPB
Xxq4 RIN/B xq5/VPB xq5/VPB RIN/B xq4/A xq4/X xq4/B xq4/a_285_297# xq4/a_35_297# sky130_fd_sc_hd__xor2_1
Xdff2 RIN/B xq1/VPB RIN/B xq1/VPB xq3/A dff2/D dff6/CLK dff2/a_891_413# dff2/a_193_47#
+ dff2/a_381_47# dff2/a_1062_300# dff2/a_475_413# dff2/a_634_183# dff2/a_27_47# sky130_fd_sc_hd__dfxtp_4
Xxq5 RIN/B xq5/VPB xq5/VPB RIN/B xq5/A xq5/X xq5/B xq5/a_285_297# xq5/a_35_297# sky130_fd_sc_hd__xor2_1
Xdff3 RIN/B xq1/VPB RIN/B xq1/VPB xq4/A dff3/D dff6/CLK dff3/a_891_413# dff3/a_193_47#
+ dff3/a_381_47# dff3/a_1062_300# dff3/a_475_413# dff3/a_634_183# dff3/a_27_47# sky130_fd_sc_hd__dfxtp_4
Xxq6 RIN/B xq6/VPB xq6/VPB RIN/B xq6/A xq6/X xq6/B xq6/a_285_297# xq6/a_35_297# sky130_fd_sc_hd__xor2_1
Xdff4 RIN/B xq1/VPB RIN/B xq1/VPB xq5/A dff4/D dff6/CLK dff4/a_891_413# dff4/a_193_47#
+ dff4/a_381_47# dff4/a_1062_300# dff4/a_475_413# dff4/a_634_183# dff4/a_27_47# sky130_fd_sc_hd__dfxtp_4
Xdff5 RIN/B xq1/VPB RIN/B xq1/VPB xq6/A dff5/D dff6/CLK dff5/a_891_413# dff5/a_193_47#
+ dff5/a_381_47# dff5/a_1062_300# dff5/a_475_413# dff5/a_634_183# dff5/a_27_47# sky130_fd_sc_hd__dfxtp_4
Xdff6 RIN/B xq3/VPB RIN/B xq3/VPB xq2/A dff6/D dff6/CLK dff6/a_891_413# dff6/a_193_47#
+ dff6/a_381_47# dff6/a_1062_300# dff6/a_475_413# dff6/a_634_183# dff6/a_27_47# sky130_fd_sc_hd__dfxtp_4
XRIN RIN/R1_1 RIN/R1_1 RIN/B CM1/C1 RIN/R2_0 sky130_fd_pr__res_xhigh_po_0p35_Y3K97R
Xmon xq3/VPB RIN/B mon/X mon/A xq3/VPB RIN/B mon/a_27_47# sky130_fd_sc_hd__buf_4
XCM0 CM1/C1 CM1/C2 RIN/B sky130_fd_pr__cap_mim_m3_1_4SMZ5E
XCM1 CM1/C1 CM1/C2 RIN/B sky130_fd_pr__cap_mim_m3_1_4SMZ5E
Xdq0 xq0/B dq6/CLK xq0/A xq1/VPB RIN/B xq1/VPB RIN/B dq0/a_891_413# dq0/a_466_413#
+ dq0/a_1059_315# dq0/a_193_47# dq0/a_634_159# dq0/a_381_47# dq0/a_27_47# sky130_fd_sc_hd__dfxtp_1
Xdq1 xq1/B dq6/CLK xq1/A xq1/VPB RIN/B xq1/VPB RIN/B dq1/a_891_413# dq1/a_466_413#
+ dq1/a_1059_315# dq1/a_193_47# dq1/a_634_159# dq1/a_381_47# dq1/a_27_47# sky130_fd_sc_hd__dfxtp_1
XRD0 RD0/R1_5 RD0/R1_3 RD0/R1_3 RD0/R1_1 RD0/R1_1 RIN/B CM1/C1 RD0/R2_4 RD0/R2_4 RD0/R2_2
+ RD0/R2_2 xq0/X RD0/R1_5 sky130_fd_pr__res_xhigh_po_0p35_PZSUGD
Xdq2 xq2/B dq6/CLK xq2/A xq3/VPB RIN/B xq3/VPB RIN/B dq2/a_891_413# dq2/a_466_413#
+ dq2/a_1059_315# dq2/a_193_47# dq2/a_634_159# dq2/a_381_47# dq2/a_27_47# sky130_fd_sc_hd__dfxtp_1
XRD1 RD1/R1_5 RD1/R1_3 RD1/R1_3 RD1/R1_1 RD1/R1_1 RIN/B CM1/C1 RD1/R2_4 RD1/R2_4 RD1/R2_2
+ RD1/R2_2 xq1/X RD1/R1_5 sky130_fd_pr__res_xhigh_po_0p35_PZSUGD
Xdq3 xq3/B dq6/CLK xq3/A xq3/VPB RIN/B xq3/VPB RIN/B dq3/a_891_413# dq3/a_466_413#
+ dq3/a_1059_315# dq3/a_193_47# dq3/a_634_159# dq3/a_381_47# dq3/a_27_47# sky130_fd_sc_hd__dfxtp_1
XRD2 RD2/R1_5 RD2/R1_3 RD2/R1_3 RD2/R1_1 RD2/R1_1 RIN/B CM1/C1 RD2/R2_4 RD2/R2_4 RD2/R2_2
+ RD2/R2_2 xq2/X RD2/R1_5 sky130_fd_pr__res_xhigh_po_0p35_PZSUGD
Xdq4 xq4/B dq6/CLK xq4/A xq5/VPB RIN/B xq5/VPB RIN/B dq4/a_891_413# dq4/a_466_413#
+ dq4/a_1059_315# dq4/a_193_47# dq4/a_634_159# dq4/a_381_47# dq4/a_27_47# sky130_fd_sc_hd__dfxtp_1
Xxq0 RIN/B xq1/VPB xq1/VPB RIN/B xq0/A xq0/X xq0/B xq0/a_285_297# xq0/a_35_297# sky130_fd_sc_hd__xor2_1
XRD3 RD3/R1_5 RD3/R1_3 RD3/R1_3 RD3/R1_1 RD3/R1_1 RIN/B CM1/C1 RD3/R2_4 RD3/R2_4 RD3/R2_2
+ RD3/R2_2 xq3/X RD3/R1_5 sky130_fd_pr__res_xhigh_po_0p35_PZSUGD
XRD4 RD4/R1_5 RD4/R1_3 RD4/R1_3 RD4/R1_1 RD4/R1_1 RIN/B CM1/C1 RD4/R2_4 RD4/R2_4 RD4/R2_2
+ RD4/R2_2 xq4/X RD4/R1_5 sky130_fd_pr__res_xhigh_po_0p35_PZSUGD
Xdq5 xq5/B dq6/CLK xq5/A xq5/VPB RIN/B xq5/VPB RIN/B dq5/a_891_413# dq5/a_466_413#
+ dq5/a_1059_315# dq5/a_193_47# dq5/a_634_159# dq5/a_381_47# dq5/a_27_47# sky130_fd_sc_hd__dfxtp_1
Xxq1 RIN/B xq1/VPB xq1/VPB RIN/B xq1/A xq1/X xq1/B xq1/a_285_297# xq1/a_35_297# sky130_fd_sc_hd__xor2_1
XRD5 RD5/R1_5 RD5/R1_3 RD5/R1_3 RD5/R1_1 RD5/R1_1 RIN/B CM1/C1 RD5/R2_4 RD5/R2_4 RD5/R2_2
+ RD5/R2_2 xq5/X RD5/R1_5 sky130_fd_pr__res_xhigh_po_0p35_PZSUGD
Xdff0 RIN/B xq3/VPB RIN/B xq3/VPB xq0/A mon/A dff6/CLK dff0/a_891_413# dff0/a_193_47#
+ dff0/a_381_47# dff0/a_1062_300# dff0/a_475_413# dff0/a_634_183# dff0/a_27_47# sky130_fd_sc_hd__dfxtp_4
Xdq6 xq6/B dq6/CLK xq6/A xq6/VPB RIN/B xq6/VPB RIN/B dq6/a_891_413# dq6/a_466_413#
+ dq6/a_1059_315# dq6/a_193_47# dq6/a_634_159# dq6/a_381_47# dq6/a_27_47# sky130_fd_sc_hd__dfxtp_1
Xxq2 RIN/B xq3/VPB xq3/VPB RIN/B xq2/A xq2/X xq2/B xq2/a_285_297# xq2/a_35_297# sky130_fd_sc_hd__xor2_1
XRD6 RD6/R1_5 RD6/R1_3 RD6/R1_3 RD6/R1_1 RD6/R1_1 RIN/B CM1/C1 RD6/R2_4 RD6/R2_4 RD6/R2_2
+ RD6/R2_2 xq6/X RD6/R1_5 sky130_fd_pr__res_xhigh_po_0p35_PZSUGD
Xdff1 RIN/B xq3/VPB RIN/B xq3/VPB xq1/A dff1/D dff6/CLK dff1/a_891_413# dff1/a_193_47#
+ dff1/a_381_47# dff1/a_1062_300# dff1/a_475_413# dff1/a_634_183# dff1/a_27_47# sky130_fd_sc_hd__dfxtp_4
Xxq3 RIN/B xq3/VPB xq3/VPB RIN/B xq3/A xq3/X xq3/B xq3/a_285_297# xq3/a_35_297# sky130_fd_sc_hd__xor2_1
X0 dff1/D mon/A a_2366_39596# w_440_39556# sky130_fd_pr__pfet_01v8 ad=0.33 pd=2.66 as=0.15 ps=1.3 w=1 l=0.15
X1 CM1/C2 a_3032_27474# w_2846_27270# w_2846_27270# sky130_fd_pr__pfet_01v8 ad=0.74 pd=4.37 as=1.32 ps=8.66 w=4 l=1
X2 dff6/D dff1/D a_2846_39596# w_440_39556# sky130_fd_pr__pfet_01v8 ad=0.33 pd=2.66 as=0.15 ps=1.3 w=1 l=0.15
X3 mon/A dff5/D a_1886_39236# RIN/B sky130_fd_pr__nfet_01v8 ad=0.165 pd=1.66 as=0.075 ps=0.8 w=0.5 l=0.15
X4 CM1/C1 a_4654_26861# CM1/C2 RIN/B sky130_fd_pr__nfet_01v8 ad=0.1386 pd=1.5 as=0.1386 ps=1.5 w=0.42 l=0.15
X5 mon/A dff5/D a_1886_39596# w_440_39556# sky130_fd_pr__pfet_01v8 ad=0.33 pd=2.66 as=0.15 ps=1.3 w=1 l=0.15
X6 a_2306_26380# a_1906_26237# RIN/B RIN/B sky130_fd_pr__nfet_01v8 ad=0.37 pd=2.37 as=0.66 ps=4.66 w=2 l=2
X7 RIN/B dff5/D RIN/B RIN/B sky130_fd_pr__nfet_01v8 ad=0.49 pd=3.5 as=22.80923 ps=225.33 w=1.4 l=2.86
X8 w_2846_27270# a_3032_27474# a_3032_27474# w_2846_27270# sky130_fd_pr__pfet_01v8 ad=1.32 pd=8.66 as=0.74 ps=4.37 w=4 l=1
X9 a_3326_39236# a_1066_39096# RIN/B RIN/B sky130_fd_pr__nfet_01v8 ad=0.075 pd=0.8 as=0.165 ps=1.66 w=0.5 l=1
X10 a_3806_39236# a_1066_39096# RIN/B RIN/B sky130_fd_pr__nfet_01v8 ad=0.075 pd=0.8 as=0.165 ps=1.66 w=0.5 l=1
X11 a_586_39570# CM1/C2 a_520_37976# RIN/B sky130_fd_pr__nfet_01v8 ad=1.32 pd=8.66 as=1.32 ps=8.66 w=4 l=1
X12 a_3326_39596# a_586_39570# w_440_39556# w_440_39556# sky130_fd_pr__pfet_01v8 ad=0.15 pd=1.3 as=0.33 ps=2.66 w=1 l=1
X13 a_2366_39236# a_1066_39096# RIN/B RIN/B sky130_fd_pr__nfet_01v8 ad=0.075 pd=0.8 as=0.165 ps=1.66 w=0.5 l=1
X14 a_2366_39596# a_586_39570# w_440_39556# w_440_39556# sky130_fd_pr__pfet_01v8 ad=0.15 pd=1.3 as=0.33 ps=2.66 w=1 l=1
X15 a_3806_39596# a_586_39570# w_440_39556# w_440_39556# sky130_fd_pr__pfet_01v8 ad=0.15 pd=1.3 as=0.33 ps=2.66 w=1 l=1
X16 a_2846_39236# a_1066_39096# RIN/B RIN/B sky130_fd_pr__nfet_01v8 ad=0.075 pd=0.8 as=0.165 ps=1.66 w=0.5 l=1
X17 a_3032_27474# a_3032_26237# a_2306_26380# RIN/B sky130_fd_pr__nfet_01v8 ad=0.74 pd=4.37 as=1.32 ps=8.66 w=4 l=1
X18 a_2306_26380# CM1/C1 CM1/C2 RIN/B sky130_fd_pr__nfet_01v8 ad=1.32 pd=8.66 as=0.74 ps=4.37 w=4 l=1
X19 a_2846_39596# a_586_39570# w_440_39556# w_440_39556# sky130_fd_pr__pfet_01v8 ad=0.15 pd=1.3 as=0.33 ps=2.66 w=1 l=1
X20 a_1886_39236# a_1066_39096# RIN/B RIN/B sky130_fd_pr__nfet_01v8 ad=0.075 pd=0.8 as=0.165 ps=1.66 w=0.5 l=1
X21 a_1886_39596# a_586_39570# w_440_39556# w_440_39556# sky130_fd_pr__pfet_01v8 ad=0.15 pd=1.3 as=0.33 ps=2.66 w=1 l=1
X22 a_1066_39096# a_1066_39096# RIN/B RIN/B sky130_fd_pr__nfet_01v8 ad=0.165 pd=1.66 as=0.165 ps=1.66 w=0.5 l=1
X23 CM1/C2 CM1/C1 a_2306_26380# RIN/B sky130_fd_pr__nfet_01v8 ad=0.74 pd=4.37 as=1.32 ps=8.66 w=4 l=1
X24 a_1066_39096# a_586_39570# w_440_39556# w_440_39556# sky130_fd_pr__pfet_01v8 ad=0.33 pd=2.66 as=0.33 ps=2.66 w=1 l=1
X25 RIN/B dff4/D RIN/B RIN/B sky130_fd_pr__nfet_01v8 ad=0.49 pd=3.5 as=0 ps=0 w=1.4 l=2.86
X26 RIN/B a_1906_26237# a_2306_26380# RIN/B sky130_fd_pr__nfet_01v8 ad=0.66 pd=4.66 as=0.37 ps=2.37 w=2 l=2
X27 RIN/B dff2/D RIN/B RIN/B sky130_fd_pr__nfet_01v8 ad=0.49 pd=3.5 as=0 ps=0 w=1.4 l=2.86
X28 dff4/D dff3/D a_4286_39236# RIN/B sky130_fd_pr__nfet_01v8 ad=0.165 pd=1.66 as=0.075 ps=0.8 w=0.5 l=0.15
X29 RIN/B dff3/D RIN/B RIN/B sky130_fd_pr__nfet_01v8 ad=0.49 pd=3.5 as=0 ps=0 w=1.4 l=2.86
X30 dff5/D dff4/D a_4766_39236# RIN/B sky130_fd_pr__nfet_01v8 ad=0.165 pd=1.66 as=0.075 ps=0.8 w=0.5 l=0.15
X31 RIN/B dff1/D RIN/B RIN/B sky130_fd_pr__nfet_01v8 ad=0.49 pd=3.5 as=0 ps=0 w=1.4 l=2.86
X32 a_586_39570# a_586_39570# w_440_39556# w_440_39556# sky130_fd_pr__pfet_01v8 ad=0.33 pd=2.66 as=0.33 ps=2.66 w=1 l=1
X33 dff4/D dff3/D a_4286_39596# w_440_39556# sky130_fd_pr__pfet_01v8 ad=0.33 pd=2.66 as=0.15 ps=1.3 w=1 l=0.15
X34 dff2/D dff6/D a_3326_39236# RIN/B sky130_fd_pr__nfet_01v8 ad=0.165 pd=1.66 as=0.075 ps=0.8 w=0.5 l=0.15
X35 RIN/B dff6/D RIN/B RIN/B sky130_fd_pr__nfet_01v8 ad=0.49 pd=3.5 as=0 ps=0 w=1.4 l=2.86
X36 a_2306_26380# a_3032_26237# a_3032_27474# RIN/B sky130_fd_pr__nfet_01v8 ad=1.32 pd=8.66 as=0.74 ps=4.37 w=4 l=1
X37 dff2/D dff6/D a_3326_39596# w_440_39556# sky130_fd_pr__pfet_01v8 ad=0.33 pd=2.66 as=0.15 ps=1.3 w=1 l=0.15
X38 dff5/D dff4/D a_4766_39596# w_440_39556# sky130_fd_pr__pfet_01v8 ad=0.33 pd=2.66 as=0.15 ps=1.3 w=1 l=0.15
X39 dff3/D dff2/D a_3806_39236# RIN/B sky130_fd_pr__nfet_01v8 ad=0.165 pd=1.66 as=0.075 ps=0.8 w=0.5 l=0.15
X40 dff3/D dff2/D a_3806_39596# w_440_39556# sky130_fd_pr__pfet_01v8 ad=0.33 pd=2.66 as=0.15 ps=1.3 w=1 l=0.15
X41 a_4286_39236# a_1066_39096# RIN/B RIN/B sky130_fd_pr__nfet_01v8 ad=0.075 pd=0.8 as=0.165 ps=1.66 w=0.5 l=1
X42 a_4286_39596# a_586_39570# w_440_39556# w_440_39556# sky130_fd_pr__pfet_01v8 ad=0.15 pd=1.3 as=0.33 ps=2.66 w=1 l=1
X43 a_4766_39236# a_1066_39096# RIN/B RIN/B sky130_fd_pr__nfet_01v8 ad=0.075 pd=0.8 as=0.165 ps=1.66 w=0.5 l=1
X44 a_4766_39596# a_586_39570# w_440_39556# w_440_39556# sky130_fd_pr__pfet_01v8 ad=0.15 pd=1.3 as=0.33 ps=2.66 w=1 l=1
X45 w_2846_27270# a_3032_27474# CM1/C2 w_2846_27270# sky130_fd_pr__pfet_01v8 ad=1.32 pd=8.66 as=0.74 ps=4.37 w=4 l=1
X46 a_3032_27474# a_3032_27474# w_2846_27270# w_2846_27270# sky130_fd_pr__pfet_01v8 ad=0.74 pd=4.37 as=1.32 ps=8.66 w=4 l=1
X47 dff1/D mon/A a_2366_39236# RIN/B sky130_fd_pr__nfet_01v8 ad=0.165 pd=1.66 as=0.075 ps=0.8 w=0.5 l=0.15
X48 dff6/D dff1/D a_2846_39236# RIN/B sky130_fd_pr__nfet_01v8 ad=0.165 pd=1.66 as=0.075 ps=0.8 w=0.5 l=0.15
X49 RIN/B mon/A RIN/B RIN/B sky130_fd_pr__nfet_01v8 ad=0.49 pd=3.5 as=0 ps=0 w=1.4 l=2.86
C0 xq5/A dq5/a_634_159# 0.01899f
C1 xq3/VPB xq0/A 0.22887f
C2 a_3032_26237# a_4654_26861# 0.34111f
C3 xq1/A dq1/a_1059_315# 0.03011f
C4 xq3/VPB xq5/A 0.03017f
C5 xq4/A dq4/a_634_159# 0.01911f
C6 xq1/VPB dff6/CLK 0.50994f
C7 dff2/a_193_47# dff2/a_27_47# -0.01246f
C8 dff1/a_27_47# dff1/D 0.04369f
C9 dff5/a_27_47# dff6/CLK 0.03089f
C10 xq0/A mon/A 0.06409f
C11 xq1/VPB xq1/X 0.23042f
C12 xq0/A xq6/A 0.10233f
C13 xq4/X xq5/VPB 0.34018f
C14 mon/X dff6/CLK 1.06773f
C15 xq5/A dq5/a_27_47# 0.05671f
C16 xq2/A xq1/A 4.33356f
C17 dq4/a_193_47# dq5/a_193_47# 0.0272f
C18 xq5/A xq6/A 4.16104f
C19 dff5/D dff4/D 1.35777f
C20 xq2/A dff3/D 0.09281f
C21 dff3/D dff6/a_27_47# 0.01268f
C22 dff6/a_1062_300# dff1/a_27_47# 0.01095f
C23 xq3/A dff4/a_27_47# 0.01274f
C24 xq0/A dq0/a_1059_315# 0.02906f
C25 a_3032_27474# a_4654_26861# 0.06918f
C26 xq2/X xq6/X 0.10665f
C27 xq5/B xq5/VPB 0.03413f
C28 dff6/a_381_47# dff6/D 0.01244f
C29 dff0/a_27_47# dff6/CLK 0.08021f
C30 xq1/VPB xq0/A 0.25806f
C31 dff2/D dff0/a_193_47# 0.06079f
C32 xq0/A dff5/a_27_47# 0.0139f
C33 dq6/a_27_47# xq6/VPB 0.04881f
C34 dff3/a_1062_300# dff5/D 0.01128f
C35 xq1/VPB xq5/A 0.19906f
C36 dff5/a_27_47# xq5/A 0.01165f
C37 xq0/A mon/X 0.76094f
C38 xq2/A xq2/a_35_297# 0.02709f
C39 dff3/a_193_47# dff5/D 0.0554f
C40 a_586_39570# dff6/D 0.13733f
C41 dq6/CLK dq3/a_27_47# 0.02678f
C42 dff4/D dff3/D 1.25808f
C43 a_2306_26380# CM1/C2 0.73707f
C44 dff6/D dff6/CLK 0.14436f
C45 dff5/D dff3/a_27_47# 0.05556f
C46 xq0/A dff0/a_27_47# 0.01512f
C47 dq6/a_1059_315# xq6/B 0.02886f
C48 dff6/CLK dff2/a_381_47# 0.01307f
C49 dq5/a_466_413# dq4/a_466_413# 0.01384f
C50 RIN/R2_0 w_2846_27270# 0.13991f
C51 dff2/D dff4/D 0.44039f
C52 dq4/a_891_413# dq5/a_891_413# 0.01464f
C53 dff6/CLK dff0/a_475_413# 0.01144f
C54 dff3/a_1062_300# xq1/A 0.01793f
C55 xq6/B xq6/VPB 0.03493f
C56 dff5/D w_440_39556# 0.57835f
C57 dff3/a_193_47# xq1/A 0.01526f
C58 dff3/a_193_47# dff3/D 0.08276f
C59 RD4/R2_4 CM1/C1 0.01655f
C60 dff1/a_193_47# dff1/D 0.07821f
C61 xq3/VPB dff5/D 0.16441f
C62 dq1/a_27_47# dq2/a_27_47# 0.0407f
C63 xq1/A xq3/A 0.06193f
C64 a_2306_26380# CM1/C1 0.69454f
C65 xq0/A dff6/D 0.08148f
C66 xq4/A xq0/A 0.07757f
C67 xq0/X xq3/X 0.1218f
C68 dff5/D a_1066_39096# 0.3245f
C69 xq4/B xq5/B 0.02433f
C70 xq3/B xq2/B 0.02433f
C71 xq1/VPB dff4/a_27_47# 0.05835f
C72 a_586_39570# CM1/C2 0.08084f
C73 xq2/A xq0/X 0.0179f
C74 dq6/CLK dq6/a_27_47# 0.02528f
C75 xq4/A xq5/A 3.83212f
C76 xq1/A dff3/a_27_47# 0.01104f
C77 RIN/R2_0 xq4/X 0.04852f
C78 dff3/a_27_47# dff3/D 0.04436f
C79 dff5/D mon/A 0.18554f
C80 xq5/X xq1/X 0.10335f
C81 dff3/a_475_413# dff5/D 0.02909f
C82 dff1/a_193_47# dff1/a_27_47# -0.01246f
C83 xq3/X xq6/VPB 0.02886f
C84 xq3/B dq3/a_1059_315# 0.02886f
C85 w_440_39556# dff3/D 0.33455f
C86 xq2/A dff6/a_891_413# 0.01406f
C87 xq0/A dff6/CLK 1.0047f
C88 xq4/X xq4/a_285_297# 0.01862f
C89 dq4/a_193_47# dq3/a_193_47# 0.0272f
C90 xq5/A dff6/CLK 0.45337f
C91 xq3/VPB xq1/A 0.22812f
C92 xq3/VPB dff3/D 0.13328f
C93 xq2/A xq2/B 0.09776f
C94 dff5/D xq1/VPB 0.1691f
C95 dff2/D w_440_39556# 0.34216f
C96 dff5/D dff5/a_27_47# 0.07808f
C97 dff3/D a_1066_39096# 0.10762f
C98 xq2/B dq2/a_1059_315# 0.02886f
C99 xq2/X xq0/X 0.12437f
C100 dq1/a_634_159# dq0/a_634_159# 0.01245f
C101 xq2/A dq2/a_381_47# 0.01396f
C102 xq3/VPB dff2/D 0.12265f
C103 xq3/X xq5/VPB 0.02778f
C104 xq1/A xq6/A 0.07106f
C105 dff2/D a_1066_39096# 0.10842f
C106 xq1/X CM1/C1 0.14884f
C107 xq2/X xq6/VPB 0.02891f
C108 dq4/a_1059_315# dq5/a_1059_315# 0.02605f
C109 dq3/a_1059_315# dq2/a_1059_315# 0.02605f
C110 xq1/VPB dq1/a_27_47# 0.0501f
C111 xq5/X CM1/C1 0.14433f
C112 dff2/D mon/A 0.94195f
C113 xq0/A xq5/A 0.09259f
C114 dff5/D dff1/a_475_413# 0.01162f
C115 CM1/C1 CM1/C2 2.42632f
C116 xq1/VPB xq1/A 0.25569f
C117 xq1/VPB dff3/D 0.02292f
C118 xq1/A dff5/a_27_47# 0.02039f
C119 xq5/a_35_297# xq6/a_35_297# 0.01594f
C120 xq2/A dq6/CLK 0.41073f
C121 dq1/a_891_413# dq0/a_891_413# 0.01464f
C122 xq0/X xq3/A 0.0179f
C123 dff4/D dff2/a_27_47# 0.05553f
C124 dff4/a_475_413# dff6/CLK 0.02241f
C125 xq4/B xq3/B 0.02479f
C126 dff5/D dff1/a_634_183# 0.02122f
C127 xq1/a_35_297# xq1/A 0.02709f
C128 dff6/CLK dff4/a_27_47# 0.09252f
C129 dff2/D xq1/VPB 0.0216f
C130 xq2/X xq5/VPB 0.02645f
C131 dff3/a_193_47# dff6/a_891_413# 0.01276f
C132 xq5/X xq5/a_285_297# 0.01861f
C133 dff5/D dff6/D 0.12336f
C134 xq4/A dff5/D 0.02024f
C135 w_2846_27270# a_4654_26861# 0.08866f
C136 dff2/D mon/X 0.08268f
C137 dff2/a_891_413# dff6/a_27_47# 0.01003f
C138 a_3032_26237# a_2306_26380# 0.42401f
C139 xq2/A dff6/a_1062_300# 0.05329f
C140 xq2/A dff1/a_27_47# 0.01046f
C141 dq4/a_27_47# xq5/VPB 0.0501f
C142 dff3/D dff1/a_475_413# 0.02248f
C143 xq1/A dq1/a_634_159# 0.01985f
C144 dff5/D a_586_39570# 0.23205f
C145 dq2/a_193_47# dq1/a_193_47# 0.0272f
C146 xq2/A dff6/a_193_47# 0.01075f
C147 dff4/a_475_413# xq0/A 0.01094f
C148 xq1/VPB dff5/a_193_47# 0.01044f
C149 xq1/a_35_297# xq2/a_35_297# 0.01594f
C150 xq3/VPB xq0/X 0.06652f
C151 dff6/a_193_47# dff6/a_27_47# -0.01246f
C152 dff5/a_27_47# dff5/a_193_47# -0.01246f
C153 dff2/D dff0/a_27_47# 0.05572f
C154 xq0/A dff4/a_27_47# 0.02734f
C155 dff5/D dff6/CLK 0.03585f
C156 dff5/D dff3/a_634_183# 0.02103f
C157 xq1/A xq1/B 0.09776f
C158 dff4/D dff1/D 0.07892f
C159 xq5/B xq6/B 0.02479f
C160 a_3032_27474# a_2306_26380# 0.53059f
C161 dq6/CLK dq4/a_27_47# 0.02678f
C162 dq3/a_1059_315# xq3/A 0.02906f
C163 xq0/A dq0/a_634_159# 0.01899f
C164 dff5/a_475_413# xq1/A 0.01246f
C165 xq0/X xq6/A 0.0179f
C166 xq4/A xq1/A 0.42539f
C167 dq6/a_1059_315# xq6/A 0.02906f
C168 dff3/D dff6/D 0.04175f
C169 xq3/X xq4/X 6.91734f
C170 xq1/X xq6/X 0.10642f
C171 dff2/a_475_413# mon/a_27_47# 0.01337f
C172 RIN/R2_0 xq3/X 0.03758f
C173 dq2/a_466_413# dq1/a_466_413# 0.01385f
C174 xq5/X xq6/X 5.66136f
C175 xq3/B xq3/a_35_297# 0.17659f
C176 xq6/VPB xq6/A 0.14381f
C177 xq3/VPB xq2/B 0.03413f
C178 xq2/a_285_297# xq2/X 0.01866f
C179 dff3/D a_586_39570# 0.13157f
C180 dff2/D dff6/D 1.0936f
C181 dff2/D dff2/a_381_47# 0.01227f
C182 dff5/D xq0/A 0.0108f
C183 dq6/CLK xq3/A 0.53983f
C184 xq1/VPB xq0/X 0.28048f
C185 dff2/D dff0/a_475_413# 0.01854f
C186 xq2/A dq3/a_27_47# 0.01017f
C187 dff5/D xq5/A 0.01268f
C188 dff2/D a_586_39570# 0.13513f
C189 dff3/D dff6/CLK 0.04613f
C190 xq3/VPB xq5/VPB 0.02013f
C191 dff5/D dff1/a_1062_300# 0.0353f
C192 dff6/CLK dff4/a_891_413# 0.02031f
C193 dq6/CLK dq2/a_27_47# 0.02678f
C194 dff3/a_193_47# dff6/a_1062_300# 0.01098f
C195 dff2/a_891_413# xq3/A 0.01093f
C196 a_3032_26237# CM1/C2 0.3574f
C197 dff2/D dff6/CLK 0.37947f
C198 xq0/A dq1/a_27_47# 0.01017f
C199 dq4/a_1059_315# dq3/a_1059_315# 0.02513f
C200 xq2/X xq4/X 0.10668f
C201 xq3/A dq3/a_891_413# 0.02221f
C202 dq5/a_27_47# xq5/VPB 0.0501f
C203 dff2/a_475_413# dff4/D 0.02907f
C204 dff5/D dff1/a_891_413# 0.02556f
C205 RIN/R2_0 xq2/X 0.0402f
C206 dff2/a_1062_300# dff6/a_27_47# 0.01191f
C207 dff6/a_475_413# dff6/CLK 0.0188f
C208 xq6/A xq5/VPB 0.0422f
C209 xq4/A xq4/a_35_297# 0.02709f
C210 dff2/a_193_47# dff4/D 0.0554f
C211 w_440_39556# dff1/D 0.33628f
C212 a_1906_26237# a_4654_26861# 2.06397f
C213 CM1/C1 xq6/X 0.14421f
C214 dq6/CLK xq3/VPB 0.27821f
C215 xq0/A xq1/A 3.26564f
C216 xq1/VPB dff2/a_27_47# 0.05525f
C217 xq3/VPB dff1/D 0.01829f
C218 xq1/A xq5/A 0.06183f
C219 a_3032_27474# CM1/C2 0.58072f
C220 dff1/a_1062_300# xq1/A 0.05005f
C221 dff1/D a_1066_39096# 0.11111f
C222 dq6/CLK dq5/a_27_47# 0.02678f
C223 RD5/R2_2 CM1/C1 0.01627f
C224 xq5/A dff4/a_891_413# 0.01224f
C225 xq1/a_285_297# xq1/X 0.01871f
C226 dq6/CLK xq6/A 1.41229f
C227 dff2/D xq0/A 0.02272f
C228 a_3032_26237# CM1/C1 0.62564f
C229 mon/A dff1/D 0.25919f
C230 dq3/a_27_47# dq4/a_27_47# 0.0407f
C231 xq5/A dq5/a_1059_315# 0.02906f
C232 xq4/A dq4/a_193_47# 0.07787f
C233 xq3/VPB dff6/a_1062_300# 0.02168f
C234 xq3/VPB dff1/a_27_47# 0.06475f
C235 dq2/a_891_413# dq3/a_891_413# 0.01464f
C236 xq4/A xq0/X 0.0179f
C237 xq1/VPB dq0/a_27_47# 0.0501f
C238 xq1/A dff1/a_891_413# 0.0154f
C239 dq6/CLK xq1/VPB 0.29765f
C240 dff5/D a_4766_39596# 0.01037f
C241 xq0/A dff5/a_193_47# 0.01611f
C242 a_3032_27474# CM1/C1 0.03468f
C243 xq3/a_285_297# xq3/X 0.01864f
C244 dff5/a_1062_300# xq6/A 0.03745f
C245 dq3/a_27_47# xq3/A 0.05845f
C246 xq2/B xq1/B 0.02479f
C247 dq2/a_891_413# dq1/a_891_413# 0.01593f
C248 dq6/a_193_47# dq5/a_193_47# 0.0272f
C249 dq6/CLK mon/X 0.06652f
C250 xq4/B dq4/a_1059_315# 0.02886f
C251 dq3/a_466_413# dq4/a_466_413# 0.01385f
C252 xq0/X xq1/X 8.97165f
C253 dff4/D dff4/a_193_47# 0.05082f
C254 dq3/a_27_47# dq2/a_27_47# 0.03757f
C255 dq4/a_891_413# xq4/A 0.02207f
C256 xq5/X xq0/X 0.12042f
C257 dff2/a_1062_300# xq3/A 0.03402f
C258 xq3/a_35_297# xq3/A 0.02709f
C259 xq1/VPB dff5/a_1062_300# 0.01793f
C260 xq1/X xq6/VPB 0.02903f
C261 dq1/a_1059_315# dq2/a_1059_315# 0.02513f
C262 xq4/A xq5/VPB 0.15684f
C263 xq0/A dq0/a_193_47# 0.0775f
C264 xq5/X xq6/VPB 0.03062f
C265 RD6/R2_2 CM1/C1 0.01627f
C266 dff2/a_193_47# mon/A 0.01254f
C267 xq3/VPB dq3/a_27_47# 0.0501f
C268 xq0/a_35_297# xq0/B 0.17659f
C269 xq5/A dq5/a_466_413# 0.0151f
C270 xq5/a_35_297# xq5/A 0.02709f
C271 RD6/R1_1 RD5/R1_5 0.05012f
C272 xq0/X xq5/A 0.0179f
C273 dff2/a_27_47# dff6/CLK 0.10428f
C274 dq6/a_466_413# xq6/A 0.01481f
C275 xq2/A dff6/a_27_47# 0.01367f
C276 xq2/A dq2/a_1059_315# 0.02922f
C277 xq3/A dff4/a_193_47# 0.0129f
C278 dff5/D xq1/A 0.15723f
C279 dff5/D dff3/D 0.34741f
C280 dq6/CLK xq4/A 0.59373f
C281 xq1/A dq1/a_193_47# 0.08223f
C282 xq1/X xq5/VPB 0.0266f
C283 xq0/X CM1/C1 2.35994f
C284 dff1/D dff6/D 0.63189f
C285 w_2846_27270# a_2306_26380# 0.12148f
C286 xq5/X xq5/VPB 0.32365f
C287 dff5/D dff2/D 0.12333f
C288 RD5/R2_4 CM1/C1 0.01655f
C289 dff1/D a_586_39570# 0.13562f
C290 xq0/A dff2/a_27_47# 0.01492f
C291 xq1/A dq1/a_27_47# 0.0615f
C292 xq2/X xq3/X 7.73238f
C293 dff4/D mon/a_27_47# 0.0271f
C294 dq6/CLK dff6/CLK 0.16129f
C295 xq2/A dff4/D 0.02675f
C296 xq4/A dff5/a_1062_300# 0.03254f
C297 xq6/B xq6/a_35_297# 0.17659f
C298 dff0/a_193_47# dff4/D 0.04895f
C299 xq3/B xq3/A 0.09776f
C300 dff1/D dff6/CLK 0.03781f
C301 dff6/a_193_47# dff6/D 0.0509f
C302 xq2/A dq2/a_634_159# 0.01943f
C303 dff5/D dff5/a_193_47# 0.05082f
C304 xq5/A xq5/VPB 0.21072f
C305 xq1/VPB dff2/a_1062_300# 0.02498f
C306 xq4/B xq4/A 0.09776f
C307 dq6/a_27_47# dq5/a_27_47# 0.0407f
C308 dff1/a_381_47# dff1/D 0.01227f
C309 dq6/a_27_47# xq6/A 0.0553f
C310 mon/a_27_47# dff0/a_1062_300# 0.01029f
C311 xq0/A dq0/a_27_47# 0.05395f
C312 a_3032_26237# a_3032_27474# 0.36889f
C313 dff2/a_891_413# dff6/CLK 0.02687f
C314 xq1/A dff3/a_891_413# 0.01267f
C315 dff6/a_27_47# dff0/a_1062_300# 0.01014f
C316 dff0/a_891_413# dff4/D 0.02028f
C317 dff1/a_27_47# dff6/CLK 0.03314f
C318 dff3/a_634_183# dff6/a_1062_300# 0.01389f
C319 dff2/D dff3/D 0.90522f
C320 dff3/a_193_47# xq2/A 0.01706f
C321 dq3/a_466_413# xq3/A 0.01596f
C322 dq6/CLK xq0/A 0.53294f
C323 dff6/a_193_47# dff6/CLK 0.02544f
C324 dff4/D dff0/a_634_183# 0.01722f
C325 dq6/CLK xq5/A 0.80173f
C326 xq2/A xq3/A 3.91092f
C327 xq3/B xq3/VPB 0.03413f
C328 xq1/VPB dff4/a_193_47# 0.01044f
C329 xq2/A dff3/a_27_47# 0.01887f
C330 dq3/a_381_47# xq3/A 0.01402f
C331 xq1/A dff5/a_193_47# 0.02061f
C332 xq2/A dq2/a_27_47# 0.05619f
C333 dq1/a_193_47# dq0/a_193_47# 0.0272f
C334 RD0/R2_2 CM1/C1 0.01627f
C335 RD1/R1_5 RD2/R1_1 0.05012f
C336 w_2846_27270# CM1/C2 0.83412f
C337 RD3/R2_4 CM1/C1 0.01655f
C338 xq6/B xq6/A 0.09776f
C339 dff2/a_27_47# dff4/a_27_47# 0.01359f
C340 dff4/D dff0/a_1062_300# 0.02264f
C341 xq0/A dff5/a_1062_300# 0.02077f
C342 RD1/R2_4 CM1/C1 0.01655f
C343 dff2/a_475_413# dff6/CLK 0.02027f
C344 xq0/X xq6/X 0.12369f
C345 xq3/A dq3/a_193_47# 0.07981f
C346 xq0/A dq0/a_466_413# 0.01481f
C347 dff2/a_193_47# dff6/CLK 0.08286f
C348 xq4/X xq1/X 0.10427f
C349 a_2306_26380# a_1906_26237# 0.3085f
C350 dq6/a_891_413# dq5/a_891_413# 0.01593f
C351 xq3/VPB xq3/X 0.27711f
C352 RIN/R2_0 xq1/X 0.03327f
C353 dff4/a_381_47# dff4/D 0.01244f
C354 xq3/VPB mon/a_27_47# 0.09039f
C355 dff2/a_1062_300# dff6/D 0.01399f
C356 xq2/A dq2/a_891_413# 0.02236f
C357 xq2/A xq3/VPB 0.31877f
C358 xq5/X xq4/X 6.51062f
C359 RIN/R2_0 xq5/X 0.0671f
C360 xq3/VPB dff6/a_27_47# 0.06242f
C361 dff4/D xq3/A 0.02072f
C362 xq6/VPB xq6/X 0.38917f
C363 dff2/a_634_183# dff4/D 0.02114f
C364 xq1/A dq0/a_193_47# 0.01279f
C365 dq1/a_1059_315# dq0/a_1059_315# 0.02605f
C366 mon/A mon/a_27_47# 0.0521f
C367 dff4/a_1062_300# xq3/A 0.0128f
C368 w_2846_27270# CM1/C1 0.15229f
C369 RIN/R2_0 CM1/C2 1.24864f
C370 dff0/a_193_47# mon/A 0.11789f
C371 xq2/A xq6/A 0.07042f
C372 dq2/a_466_413# dq3/a_466_413# 0.01384f
C373 xq1/A xq0/X 0.0179f
C374 RD6/R2_4 CM1/C1 0.01655f
C375 xq5/A dq5/a_381_47# 0.01382f
C376 xq1/A dq1/a_466_413# 0.01667f
C377 xq2/A dq2/a_466_413# 0.01539f
C378 dff2/a_193_47# xq0/A 0.01407f
C379 dff2/a_1062_300# dff6/CLK 0.0648f
C380 xq1/a_35_297# xq0/a_35_297# 0.01441f
C381 w_440_39556# dff4/D 0.33989f
C382 xq6/a_285_297# xq6/X 0.0186f
C383 dq6/a_1059_315# dq5/a_1059_315# 0.02513f
C384 CM1/C1 RD4/R2_2 0.01627f
C385 xq2/X xq3/VPB 0.29288f
C386 xq3/VPB dff4/D 0.13509f
C387 dff3/a_193_47# dff3/a_27_47# -0.01246f
C388 xq2/A xq1/VPB 0.08772f
C389 dff3/D dff6/a_891_413# 0.03082f
C390 a_520_37976# a_586_39570# 0.08048f
C391 xq2/A dff5/a_27_47# 0.01273f
C392 dff4/D a_1066_39096# 0.0905f
C393 xq4/X CM1/C1 0.14475f
C394 RIN/R2_0 CM1/C1 0.20858f
C395 xq5/B xq5/A 0.09776f
C396 dq0/a_1059_315# xq0/B 0.02886f
C397 mon/A dff0/a_634_183# 0.02046f
C398 dq4/a_381_47# xq4/A 0.01377f
C399 dff3/a_27_47# xq3/A 0.01249f
C400 dq6/a_381_47# xq6/A 0.01362f
C401 mon/X mon/a_27_47# 0.01809f
C402 dff4/D mon/A 0.38739f
C403 xq3/A dq2/a_27_47# 0.01412f
C404 dq6/a_193_47# xq6/A 0.07768f
C405 xq3/VPB dff0/a_1062_300# 0.01526f
C406 xq0/A dff2/a_1062_300# 0.0113f
C407 dff6/CLK dff4/a_193_47# 0.06437f
C408 xq1/VPB xq0/B 0.03413f
C409 dff5/D dff1/D 0.12315f
C410 dq1/a_27_47# dq0/a_27_47# 0.03757f
C411 xq4/A dff5/a_891_413# 0.01526f
C412 xq5/a_35_297# xq4/a_35_297# 0.01441f
C413 a_2306_26380# a_4654_26861# 0.10478f
C414 dq4/a_27_47# dq5/a_27_47# 0.03757f
C415 dff0/a_381_47# mon/A 0.0127f
C416 a_1906_26237# CM1/C2 1.17998f
C417 dff2/D dff2/a_27_47# 0.04436f
C418 xq1/A dq1/a_381_47# 0.01446f
C419 dff0/a_193_47# dff0/a_27_47# -0.01246f
C420 xq1/B dq1/a_1059_315# 0.02886f
C421 xq4/A dq4/a_466_413# 0.0151f
C422 xq3/VPB xq3/A 0.21054f
C423 dq6/CLK dq1/a_27_47# 0.02678f
C424 a_520_37976# CM1/C2 0.11109f
C425 xq2/B xq2/a_35_297# 0.17659f
C426 dff5/D dff1/a_27_47# 0.05275f
C427 xq1/A dq0/a_27_47# 0.01756f
C428 xq1/VPB dff4/D 0.16206f
C429 dff5/D dff6/a_1062_300# 0.03989f
C430 RD2/R2_4 CM1/C1 0.01655f
C431 xq5/A dq5/a_193_47# 0.07871f
C432 xq3/VPB dq2/a_27_47# 0.0501f
C433 xq0/A dff4/a_193_47# 0.02754f
C434 xq1/VPB dff4/a_1062_300# 0.02079f
C435 dff4/D mon/X 0.12115f
C436 RD5/R1_1 RD4/R1_5 0.05012f
C437 dq6/CLK xq1/A 0.3522f
C438 xq3/A xq6/A 0.07104f
C439 xq6/A xq6/a_35_297# 0.02709f
C440 xq0/A dq0/a_381_47# 0.01348f
C441 RD1/R1_1 RD0/R1_5 0.05012f
C442 xq2/A xq4/A 0.06094f
C443 a_1906_26237# CM1/C1 0.45051f
C444 dff3/D dff1/D 0.24449f
C445 dff3/a_1062_300# xq1/VPB 0.02558f
C446 xq5/A dq5/a_891_413# 0.02207f
C447 dff6/D dff6/a_27_47# 0.07813f
C448 w_440_39556# a_1066_39096# 0.10549f
C449 RD3/R2_2 CM1/C1 0.01627f
C450 dff4/D dff0/a_27_47# 0.04763f
C451 xq1/B xq0/B 0.02433f
C452 xq2/A dq2/a_193_47# 0.07828f
C453 xq0/A dq0/a_891_413# 0.02207f
C454 xq0/X xq6/VPB 0.05752f
C455 w_440_39556# mon/A 0.46263f
C456 dff2/D dff1/D 0.08243f
C457 xq1/VPB xq3/A 0.2438f
C458 dff6/a_1062_300# xq1/A 0.01094f
C459 dq3/a_634_159# dq2/a_634_159# 0.01245f
C460 dff1/a_27_47# dff3/D 0.05521f
C461 dff6/a_1062_300# dff3/D 0.03463f
C462 w_2846_27270# a_3032_26237# 0.13591f
C463 dff6/CLK dff4/a_634_183# 0.01586f
C464 dq1/a_634_159# dq2/a_634_159# 0.01366f
C465 xq1/VPB dff3/a_27_47# 0.05763f
C466 xq3/VPB mon/A 0.1416f
C467 mon/a_27_47# dff6/CLK 0.04332f
C468 xq2/A dff6/CLK 0.15721f
C469 dff3/a_27_47# dff5/a_27_47# 0.01359f
C470 dff3/D dff6/a_193_47# 0.01617f
C471 xq3/X xq1/X 0.10688f
C472 xq3/VPB xq6/A 0.04247f
C473 dff0/a_193_47# dff6/CLK 0.04812f
C474 mon/A a_1066_39096# 0.1269f
C475 xq4/X xq6/X 0.10999f
C476 dff6/a_27_47# dff6/CLK 0.048f
C477 RIN/R2_0 xq6/X 0.13026f
C478 xq0/A xq0/a_35_297# 0.02709f
C479 xq5/X xq3/X 0.10657f
C480 CM1/C2 a_4654_26861# 2.5041f
C481 dq2/a_193_47# dq3/a_193_47# 0.0272f
C482 dff4/D dff6/D 0.15195f
C483 xq1/A dq1/a_891_413# 0.02303f
C484 w_2846_27270# a_3032_27474# 2.46694f
C485 xq3/A dq3/a_634_159# 0.01954f
C486 xq0/X xq5/VPB 0.06639f
C487 dff0/a_891_413# dff6/CLK 0.01706f
C488 xq4/A dq4/a_27_47# 0.05564f
C489 xq0/X xq0/a_285_297# 0.02272f
C490 xq3/VPB xq1/VPB 0.04141f
C491 dff4/D a_586_39570# 0.11449f
C492 dff4/a_27_47# dff4/a_193_47# -0.01246f
C493 RD0/R2_4 CM1/C1 0.01655f
C494 dff6/D dff0/a_1062_300# 0.04023f
C495 xq2/A xq0/A 0.24294f
C496 xq0/A dff6/a_27_47# 0.02028f
C497 dff3/a_1062_300# xq4/A 0.03272f
C498 xq3/VPB mon/X 0.18812f
C499 xq6/VPB xq5/VPB 0.02013f
C500 xq2/A xq5/A 0.39874f
C501 dff5/D dff1/a_193_47# 0.0546f
C502 dff4/D dff6/CLK 0.53376f
C503 xq2/X xq1/X 8.177f
C504 xq1/VPB xq6/A 0.17062f
C505 CM1/C1 a_4654_26861# 0.42886f
C506 dq4/a_634_159# dq5/a_634_159# 0.01245f
C507 xq2/X xq5/X 0.10411f
C508 dff2/D dff2/a_193_47# 0.08276f
C509 RIN/R2_0 a_3032_27474# 0.15057f
C510 mon/A mon/X 0.06382f
C511 dff4/a_1062_300# dff6/CLK 0.07337f
C512 xq4/A xq3/A 3.93592f
C513 xq0/A xq0/B 0.09776f
C514 xq3/X CM1/C1 0.14541f
C515 xq4/B xq4/a_35_297# 0.17659f
C516 xq3/VPB dff0/a_27_47# 0.0594f
C517 dff0/a_891_413# xq0/A 0.01442f
C518 dff6/CLK dff0/a_1062_300# 0.06646f
C519 dq6/a_891_413# xq6/A 0.02207f
C520 dq2/a_193_47# xq3/A 0.01037f
C521 dq6/CLK xq6/VPB 0.10719f
C522 xq5/B dq5/a_1059_315# 0.02886f
C523 dq6/a_634_159# dq5/a_634_159# 0.01366f
C524 RD2/R1_5 RD3/R1_1 0.05012f
C525 RD3/R1_5 RD4/R1_1 0.05012f
C526 dff3/a_193_47# dff6/CLK 0.02259f
C527 mon/A dff0/a_27_47# 0.08754f
C528 xq1/VPB dff5/a_27_47# 0.05977f
C529 xq0/A dff4/D 0.12334f
C530 w_440_39556# dff6/D 0.34745f
C531 xq1/VPB mon/X 0.03735f
C532 xq3/A dff6/CLK 0.62702f
C533 dff1/a_193_47# dff3/D 0.06104f
C534 a_3032_26237# a_1906_26237# 2.33865f
C535 dff3/a_381_47# dff3/D 0.01227f
C536 xq0/A dff4/a_1062_300# 0.02077f
C537 dff2/a_634_183# dff6/CLK 0.01694f
C538 dff6/a_634_183# dff6/CLK 0.01946f
C539 dff3/a_27_47# dff6/CLK 0.03433f
C540 xq3/VPB dff6/D 0.16383f
C541 xq3/VPB xq4/A 0.03347f
C542 dff4/a_1062_300# xq5/A 0.03803f
C543 w_440_39556# a_586_39570# 4.10394f
C544 dq1/a_466_413# dq0/a_466_413# 0.01384f
C545 dq6/a_634_159# xq6/A 0.01899f
C546 xq0/A dff0/a_1062_300# 0.03333f
C547 dq4/a_27_47# xq5/A 0.01218f
C548 dff6/D a_1066_39096# 0.1109f
C549 xq2/X CM1/C1 0.14639f
C550 xq4/A dq4/a_1059_315# 0.02906f
C551 xq3/a_35_297# xq2/a_35_297# 0.01441f
C552 dq6/CLK xq5/VPB 0.27772f
C553 mon/A dff6/D 0.13353f
C554 xq4/A dq5/a_27_47# 0.01017f
C555 xq4/A xq6/A 0.39525f
C556 a_586_39570# a_1066_39096# 0.19517f
C557 mon/X dff0/a_27_47# 0.01404f
C558 dq4/a_891_413# dq3/a_891_413# 0.01593f
C559 xq0/A xq3/A 0.59314f
C560 dq6/CLK dq0/a_27_47# 0.02515f
C561 mon/A dff0/a_475_413# 0.02815f
C562 xq0/X xq4/X 0.12084f
C563 mon/A a_586_39570# 0.18645f
C564 xq3/VPB dff6/CLK 0.4301f
C565 RIN/R2_0 xq0/X 0.04015f
C566 dq6/a_466_413# dq5/a_466_413# 0.01385f
C567 xq3/A xq5/A 0.75366f
C568 RD1/R2_2 CM1/C1 0.01627f
C569 xq4/a_35_297# xq3/a_35_297# 0.01594f
C570 xq1/VPB xq1/B 0.03413f
C571 xq3/VPB xq1/X 0.02822f
C572 dq4/a_634_159# dq3/a_634_159# 0.01366f
C573 dff3/a_27_47# xq5/A 0.01026f
C574 dff5/D dff5/a_381_47# 0.01244f
C575 xq4/X xq6/VPB 0.02901f
C576 mon/A dff6/CLK 0.26022f
C577 xq4/A xq1/VPB 0.20486f
C578 xq1/a_35_297# xq1/B 0.17659f
C579 xq5/a_35_297# xq5/B 0.17659f
C580 xq2/A dff5/D 0.1978f
C581 RD2/R2_2 CM1/C1 0.01627f
C582 dff4/D dff4/a_27_47# 0.07808f
C583 dff6/D mon/X 0.0106f
C584 xq4/B xq5/VPB 0.03413f
C585 xq3/X xq6/X 0.10745f
C586 a_4654_26861# RIN/B 2.97969f
C587 a_1906_26237# RIN/B 2.92238f
C588 a_2306_26380# RIN/B 1.54242f
C589 a_3032_26237# RIN/B 3.35237f
C590 a_3032_27474# RIN/B 1.10693f
C591 a_520_37976# RIN/B 0.35628f
C592 a_1066_39096# RIN/B 5.04505f
C593 a_586_39570# RIN/B 2.34816f
C594 w_2846_27270# RIN/B 10.92023f
C595 w_440_39556# RIN/B 10.16071f
C596 xq3/X RIN/B 1.53841f
C597 xq3/a_35_297# RIN/B 0.25274f
C598 xq1/A RIN/B 1.68262f
C599 dff1/D RIN/B 2.44967f
C600 xq3/VPB RIN/B 13.61486f
C601 dff1/a_381_47# RIN/B 0.0164f
C602 dff1/a_891_413# RIN/B 0.1612f
C603 dff1/a_1062_300# RIN/B 0.53253f
C604 dff1/a_475_413# RIN/B 0.13738f
C605 dff1/a_634_183# RIN/B 0.15022f
C606 dff1/a_193_47# RIN/B 0.27169f
C607 dff1/a_27_47# RIN/B 0.49817f
C608 RD6/R1_5 RIN/B 0.6195f
C609 RD6/R2_4 RIN/B 0.39779f
C610 RD6/R1_3 RIN/B 0.39753f
C611 RD6/R2_2 RIN/B 0.39779f
C612 RD6/R1_1 RIN/B 0.56382f
C613 xq2/a_35_297# RIN/B 0.25274f
C614 xq6/B RIN/B 0.25342f
C615 xq6/VPB RIN/B 6.06325f
C616 xq6/A RIN/B 2.73132f
C617 dq6/a_381_47# RIN/B 0.01537f
C618 dq6/a_891_413# RIN/B 0.16087f
C619 dq6/a_1059_315# RIN/B 0.24994f
C620 dq6/a_466_413# RIN/B 0.13324f
C621 dq6/a_634_159# RIN/B 0.14231f
C622 dq6/a_193_47# RIN/B 0.27323f
C623 dq6/a_27_47# RIN/B 0.47896f
C624 xq0/A RIN/B 3.47207f
C625 mon/A RIN/B 3.48695f
C626 dff6/CLK RIN/B 3.5041f
C627 dff0/a_381_47# RIN/B 0.0164f
C628 dff0/a_891_413# RIN/B 0.1612f
C629 dff0/a_1062_300# RIN/B 0.53158f
C630 dff0/a_475_413# RIN/B 0.13739f
C631 dff0/a_634_183# RIN/B 0.1503f
C632 dff0/a_193_47# RIN/B 0.27167f
C633 dff0/a_27_47# RIN/B 0.49858f
C634 RD5/R1_5 RIN/B 0.56382f
C635 RD5/R2_4 RIN/B 0.39779f
C636 RD5/R1_3 RIN/B 0.39753f
C637 RD5/R2_2 RIN/B 0.39779f
C638 RD5/R1_1 RIN/B 0.56382f
C639 xq1/a_35_297# RIN/B 0.25274f
C640 xq5/B RIN/B 0.24031f
C641 xq5/VPB RIN/B 6.79005f
C642 xq5/A RIN/B 1.82816f
C643 dq6/CLK RIN/B 6.85464f
C644 dq5/a_381_47# RIN/B 0.01537f
C645 dq5/a_891_413# RIN/B 0.16087f
C646 dq5/a_1059_315# RIN/B 0.24994f
C647 dq5/a_466_413# RIN/B 0.13324f
C648 dq5/a_634_159# RIN/B 0.14231f
C649 dq5/a_193_47# RIN/B 0.27323f
C650 dq5/a_27_47# RIN/B 0.47896f
C651 RD4/R1_5 RIN/B 0.56382f
C652 RD4/R2_4 RIN/B 0.39779f
C653 RD4/R1_3 RIN/B 0.39753f
C654 RD4/R2_2 RIN/B 0.39779f
C655 RD4/R1_1 RIN/B 0.56382f
C656 RD3/R1_5 RIN/B 0.56382f
C657 RD3/R2_4 RIN/B 0.39779f
C658 RD3/R1_3 RIN/B 0.39753f
C659 RD3/R2_2 RIN/B 0.39779f
C660 RD3/R1_1 RIN/B 0.56382f
C661 xq0/a_35_297# RIN/B 0.25292f
C662 xq4/B RIN/B 0.24031f
C663 xq4/A RIN/B 1.44321f
C664 dq4/a_381_47# RIN/B 0.01537f
C665 dq4/a_891_413# RIN/B 0.16087f
C666 dq4/a_1059_315# RIN/B 0.24994f
C667 dq4/a_466_413# RIN/B 0.13324f
C668 dq4/a_634_159# RIN/B 0.14231f
C669 dq4/a_193_47# RIN/B 0.27323f
C670 dq4/a_27_47# RIN/B 0.47896f
C671 RD2/R1_5 RIN/B 0.56382f
C672 RD2/R2_4 RIN/B 0.39779f
C673 RD2/R1_3 RIN/B 0.39753f
C674 RD2/R2_2 RIN/B 0.39779f
C675 xq2/X RIN/B 1.34863f
C676 RD2/R1_1 RIN/B 0.56326f
C677 xq3/B RIN/B 0.24031f
C678 xq3/A RIN/B 1.569f
C679 dq3/a_381_47# RIN/B 0.01537f
C680 dq3/a_891_413# RIN/B 0.16087f
C681 dq3/a_1059_315# RIN/B 0.24994f
C682 dq3/a_466_413# RIN/B 0.13324f
C683 dq3/a_634_159# RIN/B 0.14231f
C684 dq3/a_193_47# RIN/B 0.27323f
C685 dq3/a_27_47# RIN/B 0.47896f
C686 RD1/R1_5 RIN/B 0.55914f
C687 RD1/R2_4 RIN/B 0.39779f
C688 RD1/R1_3 RIN/B 0.39345f
C689 RD1/R2_2 RIN/B 0.39779f
C690 xq1/X RIN/B 1.40759f
C691 RD1/R1_1 RIN/B 0.56018f
C692 xq2/B RIN/B 0.24031f
C693 dq2/a_381_47# RIN/B 0.01537f
C694 dq2/a_891_413# RIN/B 0.16087f
C695 dq2/a_1059_315# RIN/B 0.24994f
C696 dq2/a_466_413# RIN/B 0.13324f
C697 dq2/a_634_159# RIN/B 0.14231f
C698 dq2/a_193_47# RIN/B 0.27323f
C699 dq2/a_27_47# RIN/B 0.47896f
C700 RD0/R1_5 RIN/B 0.55879f
C701 RD0/R2_4 RIN/B 0.39779f
C702 RD0/R1_3 RIN/B 0.39577f
C703 RD0/R2_2 RIN/B 0.39779f
C704 xq0/X RIN/B 1.59901f
C705 RD0/R1_1 RIN/B 0.6153f
C706 xq1/B RIN/B 0.24031f
C707 dq1/a_381_47# RIN/B 0.01537f
C708 dq1/a_891_413# RIN/B 0.16087f
C709 dq1/a_1059_315# RIN/B 0.24994f
C710 dq1/a_466_413# RIN/B 0.13324f
C711 dq1/a_634_159# RIN/B 0.14231f
C712 dq1/a_193_47# RIN/B 0.27323f
C713 dq1/a_27_47# RIN/B 0.47896f
C714 xq0/B RIN/B 0.25472f
C715 dq0/a_381_47# RIN/B 0.01537f
C716 dq0/a_891_413# RIN/B 0.16105f
C717 dq0/a_1059_315# RIN/B 0.2502f
C718 dq0/a_466_413# RIN/B 0.1332f
C719 dq0/a_634_159# RIN/B 0.14231f
C720 dq0/a_193_47# RIN/B 0.27359f
C721 dq0/a_27_47# RIN/B 0.4793f
C722 CM1/C1 RIN/B 16.24994f
C723 CM1/C2 RIN/B 28.56237f
C724 mon/X RIN/B 0.54823f
C725 mon/a_27_47# RIN/B 0.49783f
C726 RIN/R2_0 RIN/B 4.36841f
C727 RIN/R1_1 RIN/B 0.82477f
C728 xq2/A RIN/B 1.46187f
C729 dff6/D RIN/B 2.59894f
C730 dff6/a_381_47# RIN/B 0.0164f
C731 dff6/a_891_413# RIN/B 0.16063f
C732 dff6/a_1062_300# RIN/B 0.53288f
C733 dff6/a_475_413# RIN/B 0.13736f
C734 dff6/a_634_183# RIN/B 0.15128f
C735 dff6/a_193_47# RIN/B 0.27239f
C736 dff6/a_27_47# RIN/B 0.49969f
C737 dff5/D RIN/B 4.42463f
C738 dff5/a_381_47# RIN/B 0.0164f
C739 dff5/a_891_413# RIN/B 0.16096f
C740 dff5/a_1062_300# RIN/B 0.5326f
C741 dff5/a_475_413# RIN/B 0.13733f
C742 dff5/a_634_183# RIN/B 0.15031f
C743 dff5/a_193_47# RIN/B 0.27187f
C744 dff5/a_27_47# RIN/B 0.4981f
C745 dff4/D RIN/B 3.14699f
C746 dff4/a_381_47# RIN/B 0.0164f
C747 dff4/a_891_413# RIN/B 0.16094f
C748 dff4/a_1062_300# RIN/B 0.53148f
C749 dff4/a_475_413# RIN/B 0.13733f
C750 dff4/a_634_183# RIN/B 0.15031f
C751 dff4/a_193_47# RIN/B 0.27176f
C752 dff4/a_27_47# RIN/B 0.49809f
C753 xq6/X RIN/B 3.86873f
C754 xq6/a_35_297# RIN/B 0.25274f
C755 dff3/D RIN/B 2.69764f
C756 dff3/a_381_47# RIN/B 0.0164f
C757 dff3/a_891_413# RIN/B 0.16094f
C758 dff3/a_1062_300# RIN/B 0.53243f
C759 dff3/a_475_413# RIN/B 0.13775f
C760 dff3/a_634_183# RIN/B 0.15014f
C761 dff3/a_193_47# RIN/B 0.27154f
C762 dff3/a_27_47# RIN/B 0.49817f
C763 xq5/X RIN/B 0.69303f
C764 xq5/a_35_297# RIN/B 0.25274f
C765 dff2/D RIN/B 2.56453f
C766 dff2/a_381_47# RIN/B 0.0164f
C767 dff2/a_891_413# RIN/B 0.16098f
C768 dff2/a_1062_300# RIN/B 0.53165f
C769 dff2/a_475_413# RIN/B 0.13757f
C770 dff2/a_634_183# RIN/B 0.15019f
C771 dff2/a_193_47# RIN/B 0.27266f
C772 dff2/a_27_47# RIN/B 0.49836f
C773 xq1/VPB RIN/B 14.61262f
C774 xq4/X RIN/B 1.49257f
C775 xq4/a_35_297# RIN/B 0.25274f
.ends

.subckt sky130_fd_sc_hd__inv_1 VPB VNB VGND VPWR A Y
X0 Y A VGND VNB sky130_fd_pr__nfet_01v8 ad=0.169 pd=1.82 as=0.169 ps=1.82 w=0.65 l=0.15
X1 Y A VPWR VPB sky130_fd_pr__pfet_01v8_hvt ad=0.26 pd=2.52 as=0.26 ps=2.52 w=1 l=0.15
C0 Y VPWR 0.12758f
C1 VPB A 0.04506f
C2 VPWR A 0.03703f
C3 VGND VPWR 0.03382f
C4 Y A 0.0476f
C5 Y VGND 0.09984f
C6 VPB VPWR 0.05448f
C7 VGND A 0.04004f
C8 VPB Y 0.01774f
C9 VGND VNB 0.25113f
C10 Y VNB 0.0961f
C11 VPWR VNB 0.21892f
C12 A VNB 0.16664f
C13 VPB VNB 0.33898f
.ends

.subckt tt_um_arcadia1_vco_adc clk ena rst_n ua[0] ua[1] ua[2] ua[3] ua[4] ua[5] ua[6]
+ ua[7] ui_in[0] ui_in[1] ui_in[2] ui_in[3] ui_in[4] ui_in[5] ui_in[6] ui_in[7] uio_in[0]
+ uio_in[1] uio_in[2] uio_in[3] uio_in[4] uio_in[5] uio_in[6] uio_in[7] uio_out[0]
+ uio_out[1] uio_out[2] uio_out[3] uio_out[4] uio_out[5] uio_out[6] uio_out[7] uo_out[0]
+ uo_out[1] uo_out[2] uo_out[3] uo_out[4] uo_out[5] uo_out[6] uo_out[7] VGND VDPWR
XRT RT/R1_5 RT/R1_3 RT/R1_3 RT/R1_1 RT/R1_1 VGND RT/R2_7 RT/R2_6 RT/R2_6 RT/R2_4 RT/R2_4
+ RT/R2_2 RT/R2_2 VDPWR RT/R1_7 RT/R1_7 RT/R1_5 sky130_fd_pr__res_xhigh_po_0p35_4MFQX6
XRARR VGND RARR/R1_3 VGND RARR/R1_1 VGND VGND VGND RARR/R2_4 RARR/R2_3 RARR/R2_3 RARR/R2_4
+ VGND VGND sky130_fd_pr__res_xhigh_po_0p35_9LMN9P
XRB RB/R1_3 RB/R1_3 RB/R1_1 RB/R1_1 VGND RB/R2_3 RB/R2_2 RB/R2_2 VDPWR sky130_fd_pr__res_xhigh_po_0p35_V6BCNG
XhalfN irst/Y halfN/mon/A halfN/xq3/X halfN/CM1/C1 RARR/R1_1 RB/R2_3 VDPWR halfN/a_586_39570#
+ uio_out[5] RT/R2_7 uio_out[7] VGND uio_out[0] VDPWR halfN/xq4/X VDPWR clk VDPWR
+ halfN/xq6/X halfN/CM1/C2 clk halfN/dff5/D uio_out[2] uio_out[6] uio_out[1] uio_out[3]
+ VDPWR halfN/xq5/X ua[1] halfN/dff4/D uio_out[4] VGND VDPWR vco_adc_half
XhalfP irst/Y halfP/mon/A halfP/xq3/X halfP/CM1/C1 RARR/R1_3 RB/R2_3 VDPWR halfP/a_586_39570#
+ uo_out[2] RT/R2_7 uo_out[0] VGND uo_out[7] VDPWR halfP/xq4/X VDPWR clk VDPWR halfP/xq6/X
+ halfP/CM1/C2 clk halfP/dff5/D uo_out[5] uo_out[1] uo_out[6] uo_out[4] VDPWR halfP/xq5/X
+ ua[0] halfP/dff4/D uo_out[3] VGND VDPWR vco_adc_half
Xirst VDPWR VGND VGND VDPWR rst_n irst/Y sky130_fd_sc_hd__inv_1
XRBT RBT/R1_5 RBT/R1_3 RBT/R1_3 RBT/R1_1 RBT/R1_1 VGND VGND RBT/R2_6 RBT/R2_6 RBT/R2_4
+ RBT/R2_4 RBT/R2_2 RBT/R2_2 RT/R2_7 RBT/R1_7 RBT/R1_7 RBT/R1_5 sky130_fd_pr__res_xhigh_po_0p35_4MFQX6
X0 VGND RB/R2_3 RB/R2_3 VGND sky130_fd_pr__nfet_01v8 ad=0.66 pd=4.66 as=0.37 ps=2.37 w=2 l=2
X1 VGND RT/R2_7 VGND VGND sky130_fd_pr__nfet_01v8 ad=1.65 pd=10.66 as=52.25745 ps=493.85999 w=5 l=10
X2 RB/R2_3 RB/R2_3 VGND VGND sky130_fd_pr__nfet_01v8 ad=0.37 pd=2.37 as=0.66 ps=4.66 w=2 l=2
X3 VGND RT/R2_7 VGND VGND sky130_fd_pr__nfet_01v8 ad=0.925 pd=5.37 as=0 ps=0 w=5 l=10
C0 uo_out[0] clk 0.10094f
C1 clk uo_out[2] 0.01288f
C2 rst_n halfP/xq4/X 0.08343f
C3 RARR/R1_1 RARR/R1_3 0.0619f
C4 rst_n RBT/R1_5 0.04338f
C5 ui_in[4] ui_in[5] 0.03102f
C6 rst_n ua[0] 1.20019f
C7 rst_n halfP/CM1/C1 0.03883f
C8 uio_out[6] VDPWR 0.16702f
C9 RB/R2_3 RB/R2_2 0.01866f
C10 rst_n ui_in[0] 0.03102f
C11 RT/R2_2 RT/R2_7 0.03527f
C12 halfP/CM1/C2 RT/R1_5 0.01305f
C13 RT/R2_2 VDPWR 0.01663f
C14 RBT/R1_3 halfP/CM1/C2 0.01305f
C15 ua[1] RT/R2_7 0.39686f
C16 RBT/R1_1 halfP/CM1/C2 0.01305f
C17 uio_out[1] uo_out[6] 0.02244f
C18 ui_in[6] ui_in[5] 0.03102f
C19 uo_out[3] VDPWR 0.02524f
C20 uio_out[1] VDPWR 0.25349f
C21 ua[1] VDPWR 1.51738f
C22 RARR/R2_3 RARR/R2_4 0.12578f
C23 halfN/dff5/D VDPWR 0.01225f
C24 ua[1] RT/R1_3 0.01085f
C25 RT/R2_7 VDPWR 0.89892f
C26 uio_in[7] uo_out[0] 0.03274f
C27 RT/R2_7 RT/R2_6 0.05628f
C28 uo_out[6] VDPWR 0.05092f
C29 uio_out[7] VDPWR 0.73129f
C30 ena clk 0.03102f
C31 ua[1] RT/R1_7 0.01085f
C32 uo_out[4] clk 0.04242f
C33 ua[1] rst_n 3.22582f
C34 RT/R2_6 VDPWR 0.01632f
C35 RBT/R1_7 ua[1] 0.01085f
C36 rst_n RT/R2_7 0.31855f
C37 halfP/CM1/C2 halfN/CM1/C2 0.50085f
C38 ua[1] RT/R1_1 0.01085f
C39 ui_in[1] ui_in[0] 0.03102f
C40 clk uo_out[7] 0.01445f
C41 ua[1] RB/R2_3 0.4699f
C42 rst_n VDPWR 0.41505f
C43 uio_out[0] uo_out[7] 0.51433f
C44 uio_in[0] ui_in[7] 0.03102f
C45 rst_n RT/R1_3 0.04422f
C46 RB/R2_3 RT/R2_7 1.74637f
C47 clk uo_out[3] 0.01571f
C48 uio_in[2] uio_in[1] 0.03102f
C49 RBT/R2_4 VDPWR 0.01631f
C50 ui_in[2] ui_in[1] 0.03102f
C51 RARR/R1_1 halfN/CM1/C2 0.01462f
C52 RBT/R1_5 halfP/CM1/C2 0.01305f
C53 ua[1] RB/R1_3 0.05418f
C54 rst_n RT/R1_7 0.04671f
C55 RB/R2_3 VDPWR 0.08888f
C56 halfN/xq0/X VDPWR 0.01153f
C57 uo_out[5] clk 0.0201f
C58 halfN/xq3/X VDPWR 0.03075f
C59 uio_out[7] clk -0.01056f
C60 clk uo_out[6] 0.12527f
C61 RBT/R1_7 rst_n 0.04853f
C62 halfN/xq4/X VDPWR 0.03961f
C63 RT/R1_1 rst_n 0.04969f
C64 ui_in[2] ui_in[3] 0.03102f
C65 clk VDPWR 0.81983f
C66 rst_n RB/R2_3 0.02658f
C67 halfN/xq1/X VDPWR 0.01713f
C68 uio_out[5] VDPWR 0.14592f
C69 ui_in[4] ui_in[3] 0.03102f
C70 uio_in[2] uio_in[3] 0.03102f
C71 ua[1] RT/R1_5 0.01085f
C72 halfP/xq0/X rst_n 0.01872f
C73 halfN/xq5/X VDPWR 0.06883f
C74 uio_out[2] VDPWR 0.15598f
C75 rst_n clk 0.19099f
C76 halfN/xq6/X VDPWR 0.3021f
C77 RBT/R2_2 VDPWR 0.01631f
C78 ua[1] RBT/R1_3 0.01085f
C79 uio_in[0] uio_in[1] 0.03102f
C80 ua[1] RBT/R1_1 0.01085f
C81 halfP/xq6/X rst_n 0.89938f
C82 ua[1] RB/R1_1 0.05418f
C83 halfN/xq2/X VDPWR 0.02018f
C84 halfP/mon/A halfN/mon/A 0.10005f
C85 RBT/R2_6 VDPWR 0.01631f
C86 ua[1] halfP/CM1/C2 0.01272f
C87 uio_out[3] VDPWR 0.17441f
C88 halfN/CM1/C1 ua[1] 0.02078f
C89 ua[1] irst/Y 0.65176f
C90 halfP/dff5/D VDPWR 0.01225f
C91 rst_n halfP/xq3/X 0.05345f
C92 halfP/xq1/X rst_n 0.02603f
C93 rst_n RT/R1_5 0.04338f
C94 clk uo_out[1] 0.02749f
C95 irst/Y RT/R2_7 0.95269f
C96 clk uio_out[0] 0.01445f
C97 uio_in[4] uio_in[5] 0.03102f
C98 ui_in[6] ui_in[7] 0.03102f
C99 uio_out[4] VDPWR 0.14402f
C100 RBT/R1_3 rst_n 0.04338f
C101 RBT/R1_1 RT/R1_7 0.04565f
C102 irst/Y VDPWR 0.24084f
C103 halfP/CM1/C2 RT/R1_3 0.01305f
C104 rst_n RBT/R1_1 0.04671f
C105 ua[1] halfN/CM1/C2 0.82425f
C106 halfP/xq2/X rst_n 0.03421f
C107 uio_in[7] uio_in[6] 0.03102f
C108 halfP/CM1/C2 RT/R1_7 0.01305f
C109 uo_out[2] VDPWR 0.02713f
C110 rst_n halfP/CM1/C2 1.08429f
C111 rst_n irst/Y 0.18658f
C112 RBT/R1_7 halfP/CM1/C2 0.01305f
C113 RT/R1_1 halfP/CM1/C2 0.01305f
C114 RT/R2_4 RT/R2_7 0.03749f
C115 ua[1] RBT/R1_5 0.01085f
C116 halfP/xq5/X rst_n 0.17644f
C117 ua[1] ua[0] 0.03671f
C118 ua[1] halfP/CM1/C1 0.02055f
C119 irst/Y RB/R2_3 1.2307f
C120 RB/R2_2 VDPWR 0.01663f
C121 RT/R2_4 VDPWR 0.01635f
C122 uio_in[6] uio_in[5] 0.03102f
C123 halfP/CM1/C2 RARR/R1_3 0.01191f
C124 uio_in[3] uio_in[4] 0.03102f
C125 VDPWR ua[0] 2.98252f
C126 ua[2] VGND 0.14723f
C127 ua[3] VGND 0.14723f
C128 ua[4] VGND 0.14723f
C129 ua[5] VGND 0.14723f
C130 ua[6] VGND 0.14723f
C131 ua[7] VGND 0.14723f
C132 ena VGND 0.07059f
C133 ui_in[0] VGND 0.04301f
C134 ui_in[1] VGND 0.04301f
C135 ui_in[2] VGND 0.04307f
C136 ui_in[3] VGND 0.04307f
C137 ui_in[4] VGND 0.04307f
C138 ui_in[5] VGND 0.04329f
C139 ui_in[6] VGND 0.04301f
C140 ui_in[7] VGND 0.04301f
C141 uio_in[0] VGND 0.04301f
C142 uio_in[1] VGND 0.04301f
C143 uio_in[2] VGND 0.04301f
C144 uio_in[3] VGND 0.04301f
C145 uio_in[4] VGND 0.04301f
C146 uio_in[5] VGND 0.04301f
C147 uio_in[6] VGND 0.04301f
C148 uio_in[7] VGND 0.04301f
C149 RBT/R1_7 VGND 0.60865f
C150 RBT/R2_6 VGND 0.37658f
C151 RBT/R1_5 VGND 0.38618f
C152 RBT/R2_4 VGND 0.37059f
C153 RBT/R1_3 VGND 0.38618f
C154 RBT/R2_2 VGND 0.36973f
C155 RBT/R1_1 VGND 0.55583f
C156 irst/Y VGND 6.78188f
C157 rst_n VGND 1.13124f
C158 halfP/a_2306_26380# VGND 1.54242f $ **FLOATING
C159 halfP/a_3032_27474# VGND 1.1053f $ **FLOATING
C160 halfP/a_1066_39096# VGND 5.05355f $ **FLOATING
C161 halfP/a_586_39570# VGND 2.359f
C162 halfP/xq3/X VGND 1.38408f
C163 halfP/xq3/a_35_297# VGND 0.25457f
C164 uo_out[2] VGND 1.23408f
C165 halfP/dff1/D VGND 2.34494f
C166 halfP/dff1/a_381_47# VGND 0.0164f
C167 halfP/dff1/a_891_413# VGND 0.16089f
C168 halfP/dff1/a_1062_300# VGND 0.52966f
C169 halfP/dff1/a_475_413# VGND 0.13718f
C170 halfP/dff1/a_634_183# VGND 0.15021f
C171 halfP/dff1/a_193_47# VGND 0.27118f
C172 halfP/dff1/a_27_47# VGND 0.4683f
C173 halfP/RD6/R1_5 VGND 0.61861f
C174 halfP/RD6/R2_4 VGND 0.39677f
C175 halfP/RD6/R1_3 VGND 0.39666f
C176 halfP/RD6/R2_2 VGND 0.39677f
C177 halfP/RD6/R1_1 VGND 0.56073f
C178 halfP/xq2/a_35_297# VGND 0.25457f
C179 halfP/xq6/B VGND 0.19993f
C180 uo_out[0] VGND 2.18805f
C181 halfP/dq6/a_381_47# VGND 0.01537f
C182 halfP/dq6/a_891_413# VGND 0.16105f
C183 halfP/dq6/a_1059_315# VGND 0.24885f
C184 halfP/dq6/a_466_413# VGND 0.1332f
C185 halfP/dq6/a_634_159# VGND 0.14231f
C186 halfP/dq6/a_193_47# VGND 0.28426f
C187 halfP/dq6/a_27_47# VGND 0.44951f
C188 uo_out[6] VGND 1.53461f
C189 halfP/mon/A VGND 3.27388f
C190 clk VGND 15.30977f
C191 halfP/dff0/a_381_47# VGND 0.0164f
C192 halfP/dff0/a_891_413# VGND 0.16089f
C193 halfP/dff0/a_1062_300# VGND 0.52966f
C194 halfP/dff0/a_475_413# VGND 0.13718f
C195 halfP/dff0/a_634_183# VGND 0.15021f
C196 halfP/dff0/a_193_47# VGND 0.27134f
C197 halfP/dff0/a_27_47# VGND 0.46838f
C198 halfP/RD5/R1_5 VGND 0.56073f
C199 halfP/RD5/R2_4 VGND 0.39677f
C200 halfP/RD5/R1_3 VGND 0.39666f
C201 halfP/RD5/R2_2 VGND 0.39677f
C202 halfP/RD5/R1_1 VGND 0.56073f
C203 halfP/xq1/a_35_297# VGND 0.25457f
C204 halfP/xq5/B VGND 0.18682f
C205 uo_out[4] VGND 1.43409f
C206 halfP/dq5/a_381_47# VGND 0.01537f
C207 halfP/dq5/a_891_413# VGND 0.16105f
C208 halfP/dq5/a_1059_315# VGND 0.24885f
C209 halfP/dq5/a_466_413# VGND 0.1332f
C210 halfP/dq5/a_634_159# VGND 0.14231f
C211 halfP/dq5/a_193_47# VGND 0.28426f
C212 halfP/dq5/a_27_47# VGND 0.44951f
C213 halfP/RD4/R1_5 VGND 0.56073f
C214 halfP/RD4/R2_4 VGND 0.39677f
C215 halfP/RD4/R1_3 VGND 0.39666f
C216 halfP/RD4/R2_2 VGND 0.39677f
C217 halfP/RD4/R1_1 VGND 0.56073f
C218 halfP/RD3/R1_5 VGND 0.56073f
C219 halfP/RD3/R2_4 VGND 0.39677f
C220 halfP/RD3/R1_3 VGND 0.39666f
C221 halfP/RD3/R2_2 VGND 0.39677f
C222 halfP/RD3/R1_1 VGND 0.56073f
C223 halfP/xq0/a_35_297# VGND 0.25457f
C224 halfP/xq4/B VGND 0.18682f
C225 uo_out[1] VGND 1.03842f
C226 halfP/dq4/a_381_47# VGND 0.01537f
C227 halfP/dq4/a_891_413# VGND 0.16105f
C228 halfP/dq4/a_1059_315# VGND 0.24885f
C229 halfP/dq4/a_466_413# VGND 0.1332f
C230 halfP/dq4/a_634_159# VGND 0.14231f
C231 halfP/dq4/a_193_47# VGND 0.28426f
C232 halfP/dq4/a_27_47# VGND 0.44951f
C233 halfP/RD2/R1_5 VGND 0.56073f
C234 halfP/RD2/R2_4 VGND 0.39677f
C235 halfP/RD2/R1_3 VGND 0.40562f
C236 halfP/RD2/R2_2 VGND 0.39677f
C237 halfP/xq2/X VGND 1.21156f
C238 halfP/RD2/R1_1 VGND 0.56158f
C239 halfP/xq3/B VGND 0.18682f
C240 uo_out[5] VGND 1.19459f
C241 halfP/dq3/a_381_47# VGND 0.01537f
C242 halfP/dq3/a_891_413# VGND 0.16105f
C243 halfP/dq3/a_1059_315# VGND 0.24885f
C244 halfP/dq3/a_466_413# VGND 0.1332f
C245 halfP/dq3/a_634_159# VGND 0.14231f
C246 halfP/dq3/a_193_47# VGND 0.28426f
C247 halfP/dq3/a_27_47# VGND 0.44951f
C248 halfP/RD1/R1_5 VGND 0.55581f
C249 halfP/RD1/R2_4 VGND 0.39677f
C250 halfP/RD1/R1_3 VGND 0.39236f
C251 halfP/RD1/R2_2 VGND 0.39677f
C252 halfP/xq1/X VGND 1.21835f
C253 halfP/RD1/R1_1 VGND 0.5568f
C254 halfP/xq2/B VGND 0.18682f
C255 halfP/dq2/a_381_47# VGND 0.01537f
C256 halfP/dq2/a_891_413# VGND 0.16105f
C257 halfP/dq2/a_1059_315# VGND 0.24885f
C258 halfP/dq2/a_466_413# VGND 0.1332f
C259 halfP/dq2/a_634_159# VGND 0.14231f
C260 halfP/dq2/a_193_47# VGND 0.28426f
C261 halfP/dq2/a_27_47# VGND 0.44951f
C262 halfP/RD0/R1_5 VGND 0.55546f
C263 halfP/RD0/R2_4 VGND 0.39677f
C264 halfP/RD0/R1_3 VGND 0.39458f
C265 halfP/RD0/R2_2 VGND 0.39677f
C266 halfP/xq0/X VGND 1.29597f
C267 halfP/RD0/R1_1 VGND 0.61415f
C268 halfP/xq1/B VGND 0.18682f
C269 halfP/dq1/a_381_47# VGND 0.01537f
C270 halfP/dq1/a_891_413# VGND 0.16105f
C271 halfP/dq1/a_1059_315# VGND 0.24885f
C272 halfP/dq1/a_466_413# VGND 0.1332f
C273 halfP/dq1/a_634_159# VGND 0.14231f
C274 halfP/dq1/a_193_47# VGND 0.28426f
C275 halfP/dq1/a_27_47# VGND 0.44951f
C276 halfP/xq0/B VGND 0.20094f
C277 halfP/dq0/a_381_47# VGND 0.01537f
C278 halfP/dq0/a_891_413# VGND 0.16105f
C279 halfP/dq0/a_1059_315# VGND 0.24885f
C280 halfP/dq0/a_466_413# VGND 0.1332f
C281 halfP/dq0/a_634_159# VGND 0.14231f
C282 halfP/dq0/a_193_47# VGND 0.28426f
C283 halfP/dq0/a_27_47# VGND 0.44951f
C284 halfP/CM1/C1 VGND 15.614f
C285 halfP/CM1/C2 VGND 28.19343f
C286 uo_out[7] VGND 0.06158f
C287 halfP/mon/a_27_47# VGND 0.46147f
C288 ua[0] VGND 9.68089f
C289 halfP/RIN/R1_1 VGND 0.81968f
C290 uo_out[3] VGND 1.02521f
C291 halfP/dff6/D VGND 2.47015f
C292 halfP/dff6/a_381_47# VGND 0.0164f
C293 halfP/dff6/a_891_413# VGND 0.16089f
C294 halfP/dff6/a_1062_300# VGND 0.52966f
C295 halfP/dff6/a_475_413# VGND 0.13718f
C296 halfP/dff6/a_634_183# VGND 0.15021f
C297 halfP/dff6/a_193_47# VGND 0.27118f
C298 halfP/dff6/a_27_47# VGND 0.4683f
C299 halfP/dff5/D VGND 4.07731f
C300 halfP/dff5/a_381_47# VGND 0.0164f
C301 halfP/dff5/a_891_413# VGND 0.16089f
C302 halfP/dff5/a_1062_300# VGND 0.52993f
C303 halfP/dff5/a_475_413# VGND 0.13718f
C304 halfP/dff5/a_634_183# VGND 0.15021f
C305 halfP/dff5/a_193_47# VGND 0.27118f
C306 halfP/dff5/a_27_47# VGND 0.4683f
C307 halfP/dff4/D VGND 2.82023f
C308 halfP/dff4/a_381_47# VGND 0.0164f
C309 halfP/dff4/a_891_413# VGND 0.16089f
C310 halfP/dff4/a_1062_300# VGND 0.52966f
C311 halfP/dff4/a_475_413# VGND 0.13718f
C312 halfP/dff4/a_634_183# VGND 0.15021f
C313 halfP/dff4/a_193_47# VGND 0.27119f
C314 halfP/dff4/a_27_47# VGND 0.4683f
C315 halfP/xq6/X VGND 3.78998f
C316 halfP/xq6/a_35_297# VGND 0.25457f
C317 halfP/dff3/D VGND 2.47213f
C318 halfP/dff3/a_381_47# VGND 0.0164f
C319 halfP/dff3/a_891_413# VGND 0.16089f
C320 halfP/dff3/a_1062_300# VGND 0.52966f
C321 halfP/dff3/a_475_413# VGND 0.13718f
C322 halfP/dff3/a_634_183# VGND 0.15021f
C323 halfP/dff3/a_193_47# VGND 0.27118f
C324 halfP/dff3/a_27_47# VGND 0.4683f
C325 halfP/xq5/X VGND 0.56755f
C326 halfP/xq5/a_35_297# VGND 0.25457f
C327 halfP/dff2/D VGND 2.33687f
C328 halfP/dff2/a_381_47# VGND 0.0164f
C329 halfP/dff2/a_891_413# VGND 0.16089f
C330 halfP/dff2/a_1062_300# VGND 0.52966f
C331 halfP/dff2/a_475_413# VGND 0.13718f
C332 halfP/dff2/a_634_183# VGND 0.15021f
C333 halfP/dff2/a_193_47# VGND 0.27123f
C334 halfP/dff2/a_27_47# VGND 0.46832f
C335 halfP/xq4/X VGND 1.38689f
C336 halfP/xq4/a_35_297# VGND 0.25457f
C337 halfN/a_2306_26380# VGND 1.54242f $ **FLOATING
C338 RT/R2_7 VGND 17.37497f
C339 halfN/a_3032_27474# VGND 1.1053f $ **FLOATING
C340 RARR/R1_1 VGND 0.94245f
C341 halfN/a_1066_39096# VGND 5.05355f $ **FLOATING
C342 halfN/a_586_39570# VGND 2.359f
C343 halfN/xq3/X VGND 1.38586f
C344 halfN/xq3/a_35_297# VGND 0.25457f
C345 uio_out[5] VGND 1.22202f
C346 halfN/dff1/D VGND 2.34494f
C347 VDPWR VGND 0.38054p
C348 halfN/dff1/a_381_47# VGND 0.0164f
C349 halfN/dff1/a_891_413# VGND 0.16089f
C350 halfN/dff1/a_1062_300# VGND 0.52966f
C351 halfN/dff1/a_475_413# VGND 0.13718f
C352 halfN/dff1/a_634_183# VGND 0.15021f
C353 halfN/dff1/a_193_47# VGND 0.27118f
C354 halfN/dff1/a_27_47# VGND 0.4683f
C355 halfN/RD6/R1_5 VGND 0.61861f
C356 halfN/RD6/R2_4 VGND 0.39677f
C357 halfN/RD6/R1_3 VGND 0.39666f
C358 halfN/RD6/R2_2 VGND 0.39677f
C359 halfN/RD6/R1_1 VGND 0.56073f
C360 halfN/xq2/a_35_297# VGND 0.25457f
C361 halfN/xq6/B VGND 0.19993f
C362 uio_out[7] VGND 1.99507f
C363 halfN/dq6/a_381_47# VGND 0.01537f
C364 halfN/dq6/a_891_413# VGND 0.16105f
C365 halfN/dq6/a_1059_315# VGND 0.24885f
C366 halfN/dq6/a_466_413# VGND 0.1332f
C367 halfN/dq6/a_634_159# VGND 0.14231f
C368 halfN/dq6/a_193_47# VGND 0.28426f
C369 halfN/dq6/a_27_47# VGND 0.44951f
C370 uio_out[1] VGND 1.522f
C371 halfN/mon/A VGND 3.27388f
C372 halfN/dff0/a_381_47# VGND 0.0164f
C373 halfN/dff0/a_891_413# VGND 0.16089f
C374 halfN/dff0/a_1062_300# VGND 0.52966f
C375 halfN/dff0/a_475_413# VGND 0.13718f
C376 halfN/dff0/a_634_183# VGND 0.15021f
C377 halfN/dff0/a_193_47# VGND 0.27134f
C378 halfN/dff0/a_27_47# VGND 0.46838f
C379 halfN/RD5/R1_5 VGND 0.56073f
C380 halfN/RD5/R2_4 VGND 0.39677f
C381 halfN/RD5/R1_3 VGND 0.39666f
C382 halfN/RD5/R2_2 VGND 0.39677f
C383 halfN/RD5/R1_1 VGND 0.56073f
C384 halfN/xq1/a_35_297# VGND 0.25457f
C385 halfN/xq5/B VGND 0.18682f
C386 uio_out[3] VGND 1.43409f
C387 halfN/dq5/a_381_47# VGND 0.01537f
C388 halfN/dq5/a_891_413# VGND 0.16105f
C389 halfN/dq5/a_1059_315# VGND 0.24885f
C390 halfN/dq5/a_466_413# VGND 0.1332f
C391 halfN/dq5/a_634_159# VGND 0.14231f
C392 halfN/dq5/a_193_47# VGND 0.28426f
C393 halfN/dq5/a_27_47# VGND 0.44951f
C394 halfN/RD4/R1_5 VGND 0.56073f
C395 halfN/RD4/R2_4 VGND 0.39677f
C396 halfN/RD4/R1_3 VGND 0.39666f
C397 halfN/RD4/R2_2 VGND 0.39677f
C398 halfN/RD4/R1_1 VGND 0.56073f
C399 halfN/RD3/R1_5 VGND 0.56073f
C400 halfN/RD3/R2_4 VGND 0.39677f
C401 halfN/RD3/R1_3 VGND 0.39666f
C402 halfN/RD3/R2_2 VGND 0.39677f
C403 halfN/RD3/R1_1 VGND 0.56073f
C404 halfN/xq0/a_35_297# VGND 0.25457f
C405 halfN/xq4/B VGND 0.18682f
C406 uio_out[6] VGND 1.02942f
C407 halfN/dq4/a_381_47# VGND 0.01537f
C408 halfN/dq4/a_891_413# VGND 0.16105f
C409 halfN/dq4/a_1059_315# VGND 0.24885f
C410 halfN/dq4/a_466_413# VGND 0.1332f
C411 halfN/dq4/a_634_159# VGND 0.14231f
C412 halfN/dq4/a_193_47# VGND 0.28426f
C413 halfN/dq4/a_27_47# VGND 0.44951f
C414 halfN/RD2/R1_5 VGND 0.56073f
C415 halfN/RD2/R2_4 VGND 0.39677f
C416 halfN/RD2/R1_3 VGND 0.40562f
C417 halfN/RD2/R2_2 VGND 0.39677f
C418 halfN/xq2/X VGND 1.21177f
C419 halfN/RD2/R1_1 VGND 0.56158f
C420 halfN/xq3/B VGND 0.18682f
C421 uio_out[2] VGND 1.19459f
C422 halfN/dq3/a_381_47# VGND 0.01537f
C423 halfN/dq3/a_891_413# VGND 0.16105f
C424 halfN/dq3/a_1059_315# VGND 0.24885f
C425 halfN/dq3/a_466_413# VGND 0.1332f
C426 halfN/dq3/a_634_159# VGND 0.14231f
C427 halfN/dq3/a_193_47# VGND 0.28426f
C428 halfN/dq3/a_27_47# VGND 0.44951f
C429 halfN/RD1/R1_5 VGND 0.55581f
C430 halfN/RD1/R2_4 VGND 0.39677f
C431 halfN/RD1/R1_3 VGND 0.39236f
C432 halfN/RD1/R2_2 VGND 0.39677f
C433 halfN/xq1/X VGND 1.21835f
C434 halfN/RD1/R1_1 VGND 0.5568f
C435 halfN/xq2/B VGND 0.18682f
C436 halfN/dq2/a_381_47# VGND 0.01537f
C437 halfN/dq2/a_891_413# VGND 0.16105f
C438 halfN/dq2/a_1059_315# VGND 0.24885f
C439 halfN/dq2/a_466_413# VGND 0.1332f
C440 halfN/dq2/a_634_159# VGND 0.14231f
C441 halfN/dq2/a_193_47# VGND 0.28426f
C442 halfN/dq2/a_27_47# VGND 0.44951f
C443 halfN/RD0/R1_5 VGND 0.55546f
C444 halfN/RD0/R2_4 VGND 0.39677f
C445 halfN/RD0/R1_3 VGND 0.39458f
C446 halfN/RD0/R2_2 VGND 0.39677f
C447 halfN/xq0/X VGND 1.29597f
C448 halfN/RD0/R1_1 VGND 0.61415f
C449 halfN/xq1/B VGND 0.18682f
C450 halfN/dq1/a_381_47# VGND 0.01537f
C451 halfN/dq1/a_891_413# VGND 0.16105f
C452 halfN/dq1/a_1059_315# VGND 0.24885f
C453 halfN/dq1/a_466_413# VGND 0.1332f
C454 halfN/dq1/a_634_159# VGND 0.14231f
C455 halfN/dq1/a_193_47# VGND 0.28426f
C456 halfN/dq1/a_27_47# VGND 0.44951f
C457 halfN/xq0/B VGND 0.20094f
C458 halfN/dq0/a_381_47# VGND 0.01537f
C459 halfN/dq0/a_891_413# VGND 0.16105f
C460 halfN/dq0/a_1059_315# VGND 0.24885f
C461 halfN/dq0/a_466_413# VGND 0.1332f
C462 halfN/dq0/a_634_159# VGND 0.14231f
C463 halfN/dq0/a_193_47# VGND 0.28426f
C464 halfN/dq0/a_27_47# VGND 0.44951f
C465 halfN/CM1/C1 VGND 15.59816f
C466 halfN/CM1/C2 VGND 28.11435f
C467 uio_out[0] VGND 0.06158f
C468 halfN/mon/a_27_47# VGND 0.46147f
C469 ua[1] VGND 12.2795f
C470 halfN/RIN/R1_1 VGND 0.81968f
C471 uio_out[4] VGND 1.01315f
C472 halfN/dff6/D VGND 2.47015f
C473 halfN/dff6/a_381_47# VGND 0.0164f
C474 halfN/dff6/a_891_413# VGND 0.16089f
C475 halfN/dff6/a_1062_300# VGND 0.52966f
C476 halfN/dff6/a_475_413# VGND 0.13718f
C477 halfN/dff6/a_634_183# VGND 0.15021f
C478 halfN/dff6/a_193_47# VGND 0.27118f
C479 halfN/dff6/a_27_47# VGND 0.4683f
C480 halfN/dff5/D VGND 4.07731f
C481 halfN/dff5/a_381_47# VGND 0.0164f
C482 halfN/dff5/a_891_413# VGND 0.16089f
C483 halfN/dff5/a_1062_300# VGND 0.52986f
C484 halfN/dff5/a_475_413# VGND 0.13718f
C485 halfN/dff5/a_634_183# VGND 0.15021f
C486 halfN/dff5/a_193_47# VGND 0.27118f
C487 halfN/dff5/a_27_47# VGND 0.4683f
C488 halfN/dff4/D VGND 2.82023f
C489 halfN/dff4/a_381_47# VGND 0.0164f
C490 halfN/dff4/a_891_413# VGND 0.16089f
C491 halfN/dff4/a_1062_300# VGND 0.52966f
C492 halfN/dff4/a_475_413# VGND 0.13718f
C493 halfN/dff4/a_634_183# VGND 0.15021f
C494 halfN/dff4/a_193_47# VGND 0.27119f
C495 halfN/dff4/a_27_47# VGND 0.4683f
C496 halfN/xq6/X VGND 3.84588f
C497 halfN/xq6/a_35_297# VGND 0.25457f
C498 halfN/dff3/D VGND 2.47213f
C499 halfN/dff3/a_381_47# VGND 0.0164f
C500 halfN/dff3/a_891_413# VGND 0.16089f
C501 halfN/dff3/a_1062_300# VGND 0.52966f
C502 halfN/dff3/a_475_413# VGND 0.13718f
C503 halfN/dff3/a_634_183# VGND 0.15021f
C504 halfN/dff3/a_193_47# VGND 0.27118f
C505 halfN/dff3/a_27_47# VGND 0.4683f
C506 halfN/xq5/X VGND 0.57139f
C507 halfN/xq5/a_35_297# VGND 0.25457f
C508 halfN/dff2/D VGND 2.33687f
C509 halfN/dff2/a_381_47# VGND 0.0164f
C510 halfN/dff2/a_891_413# VGND 0.16089f
C511 halfN/dff2/a_1062_300# VGND 0.52966f
C512 halfN/dff2/a_475_413# VGND 0.13718f
C513 halfN/dff2/a_634_183# VGND 0.15021f
C514 halfN/dff2/a_193_47# VGND 0.27123f
C515 halfN/dff2/a_27_47# VGND 0.46832f
C516 halfN/xq4/X VGND 1.38832f
C517 halfN/xq4/a_35_297# VGND 0.25457f
C518 RB/R2_3 VGND 9.833f
C519 RB/R1_3 VGND 0.60464f
C520 RB/R2_2 VGND 0.36641f
C521 RB/R1_1 VGND 0.60517f
C522 RARR/R1_3 VGND 1.00474f
C523 RARR/R2_3 VGND 0.39758f
C524 RARR/R2_4 VGND 0.59255f
C525 RT/R1_7 VGND 0.55583f
C526 RT/R2_6 VGND 0.3693f
C527 RT/R1_5 VGND 0.38618f
C528 RT/R2_4 VGND 0.36952f
C529 RT/R1_3 VGND 0.38618f
C530 RT/R2_2 VGND 0.36939f
C531 RT/R1_1 VGND 0.60823f
.ends
