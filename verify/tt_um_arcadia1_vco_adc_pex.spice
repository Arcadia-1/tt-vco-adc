* NGSPICE file created from tt_um_arcadia1_vco_adc.ext - technology: sky130A

.subckt tt_um_arcadia1_vco_adc clk ena rst_n ua[0] ua[1] ua[2] ua[3] ua[4] ua[5] ua[6]
+ ua[7] ui_in[0] ui_in[1] ui_in[2] ui_in[3] ui_in[4] ui_in[5] ui_in[6] ui_in[7] uio_in[0]
+ uio_in[1] uio_in[2] uio_in[3] uio_in[4] uio_in[5] uio_in[6] uio_in[7] uio_oe[0]
+ uio_oe[1] uio_oe[2] uio_oe[3] uio_oe[4] uio_oe[5] uio_oe[6] uio_oe[7] uio_out[0]
+ uio_out[1] uio_out[2] uio_out[3] uio_out[4] uio_out[5] uio_out[6] uio_out[7] uo_out[0]
+ uo_out[1] uo_out[2] uo_out[3] uo_out[4] uo_out[5] uo_out[6] uo_out[7] VGND VDPWR
X0 a_2799_42141# halfN/xq2.B a_3185_42167# VDPWR sky130_fd_pr__pfet_01v8_hvt ad=0.26 pd=2.52 as=0.135 ps=1.27 w=1 l=0.15
X1 VGND a_15814_42141# a_15772_42545# VGND sky130_fd_pr__nfet_01v8 ad=0.12095 pd=1.085 as=0.0696 ps=0.765 w=0.42 l=0.15
X2 a_25078_41989# a_24805_41623# a_24993_41623# VDPWR sky130_fd_pr__pfet_01v8_hvt ad=0.06825 pd=0.745 as=0.05775 ps=0.695 w=0.42 l=0.15
X3 uio_oe[7] VDPWR sky130_fd_pr__res_generic_po w=0.48 l=0.5
X4 halfP/obuf3.A a_18355_42141# VGND VGND sky130_fd_pr__nfet_01v8 ad=0.169 pd=1.82 as=0.08775 ps=0.92 w=0.65 l=0.15
X5 uio_out[5] a_10411_41597# VDPWR VDPWR sky130_fd_pr__pfet_01v8_hvt ad=0.135 pd=1.27 as=0.135 ps=1.27 w=1 l=0.15
X6 VDPWR a_18171_41891# a_18087_41989# VDPWR sky130_fd_pr__pfet_01v8_hvt ad=0.1113 pd=1.37 as=0.0882 ps=0.84 w=0.42 l=0.15
X7 a_16090_42823# a_15922_43077# VDPWR VDPWR sky130_fd_pr__pfet_01v8_hvt ad=0.1095 pd=1.075 as=0.17887 ps=1.26 w=0.75 l=0.15
X8 a_18271_42167# a_17489_42173# a_18187_42167# VDPWR sky130_fd_pr__pfet_01v8_hvt ad=0.0882 pd=0.84 as=0.0567 ps=0.69 w=0.42 l=0.15
X9 VGND a_12527_41597# uio_out[1] VGND sky130_fd_pr__nfet_01v8 ad=0.08775 pd=0.92 as=0.08775 ps=0.92 w=0.65 l=0.15
X10 halfN/CM1.C2 halfN/RIN.R2_1 a_5356_24748# VGND sky130_fd_pr__nfet_01v8 ad=2.22 pd=12.37 as=2.22 ps=12.37 w=12 l=3
X11 a_3185_41873# halfN/xq3.A VDPWR VDPWR sky130_fd_pr__pfet_01v8_hvt ad=0.135 pd=1.27 as=0.135 ps=1.27 w=1 l=0.15
X12 RBT.R1_6 RBT.R2_5 VGND sky130_fd_pr__res_xhigh_po_0p35 l=4.38
X13 a_18046_39596# a_15306_39570# VDPWR VDPWR sky130_fd_pr__pfet_01v8 ad=0.15 pd=1.3 as=0.33 ps=2.66 w=1 l=1
X14 a_12527_41597# halfN/xq0.A VGND VGND sky130_fd_pr__nfet_01v8 ad=0.169 pd=1.82 as=0.08775 ps=0.92 w=0.65 l=0.15
X15 a_17888_42545# a_17489_42173# a_17762_42167# VGND sky130_fd_pr__special_nfet_01v8 ad=0.0696 pd=0.765 as=0.0621 ps=0.705 w=0.36 l=0.15
X16 a_26369_42167# halfP/xq2.A VDPWR VDPWR sky130_fd_pr__pfet_01v8_hvt ad=0.135 pd=1.27 as=0.135 ps=1.27 w=1 l=0.15
X17 halfP/RDA.R1_17 halfP/RIN.R2_1 VGND sky130_fd_pr__res_xhigh_po_0p35 l=30.3
X18 VDPWR a_9954_39570# a_11814_39596# VDPWR sky130_fd_pr__pfet_01v8 ad=0.33 pd=2.66 as=0.15 ps=1.3 w=1 l=1
X19 a_2799_40720# halfN/obuf3.A VGND VGND sky130_fd_pr__nfet_01v8 ad=0.08775 pd=0.92 as=0.08775 ps=0.92 w=0.65 l=0.15
X20 halfP/RDA.R1_17 halfP/RDA.R2_16 VGND sky130_fd_pr__res_xhigh_po_0p35 l=30.3
X21 VGND a_25671_40803# a_25629_40535# VGND sky130_fd_pr__nfet_01v8 ad=0.1092 pd=1.36 as=0.066 ps=0.745 w=0.42 l=0.15
X22 halfP/obuf6.A a_16515_42979# VGND VGND sky130_fd_pr__nfet_01v8 ad=0.169 pd=1.82 as=0.08775 ps=0.92 w=0.65 l=0.15
X23 a_12863_42399# a_12959_42399# VDPWR VDPWR sky130_fd_pr__pfet_01v8_hvt ad=0.27 pd=2.54 as=0.135 ps=1.27 w=1 l=0.15
X24 a_13563_41623# a_13434_41897# a_13143_41597# VGND sky130_fd_pr__special_nfet_01v8 ad=0.0989 pd=0.995 as=0.0684 ps=0.74 w=0.36 l=0.15
X25 VDPWR a_4018_42685# a_3947_42711# VDPWR sky130_fd_pr__pfet_01v8_hvt ad=0.17887 pd=1.26 as=0.1095 ps=1.075 w=0.75 l=0.15
X26 VDPWR a_13427_41597# a_13434_41897# VDPWR sky130_fd_pr__pfet_01v8_hvt ad=0.0864 pd=0.91 as=0.1664 ps=1.8 w=0.64 l=0.15
X27 a_17086_39236# a_15786_39096# VGND VGND sky130_fd_pr__nfet_01v8 ad=0.075 pd=0.8 as=0.165 ps=1.66 w=0.5 l=1
X28 a_4018_43532# a_3818_43377# a_4167_43621# VGND sky130_fd_pr__special_nfet_01v8 ad=0.0621 pd=0.705 as=0.0696 ps=0.765 w=0.36 l=0.15
X29 VGND halfN/dff4.D a_13337_43633# VGND sky130_fd_pr__nfet_01v8 ad=0.1092 pd=1.36 as=0.0813 ps=0.83 w=0.42 l=0.15
X30 a_18137_43255# halfP/dff5.D VGND VGND sky130_fd_pr__nfet_01v8 ad=0.0813 pd=0.83 as=0.1092 ps=1.36 w=0.42 l=0.15
X31 VDPWR a_13047_41775# halfN/xq0.A VDPWR sky130_fd_pr__pfet_01v8_hvt ad=0.135 pd=1.27 as=0.26 ps=2.52 w=1 l=0.15
X32 irst.Y rst_n VGND VGND sky130_fd_pr__nfet_01v8 ad=0.169 pd=1.82 as=0.169 ps=1.82 w=0.65 l=0.15
X33 VGND a_3811_40509# a_3818_40809# VGND sky130_fd_pr__nfet_01v8 ad=0.0567 pd=0.69 as=0.1092 ps=1.36 w=0.42 l=0.15
X34 VGND a_16531_43255# a_16699_43229# VGND sky130_fd_pr__nfet_01v8 ad=0.08775 pd=0.92 as=0.169 ps=1.82 w=0.65 l=0.15
X35 VGND a_11518_41597# a_11447_41623# VGND sky130_fd_pr__nfet_01v8 ad=0.12095 pd=1.085 as=0.0989 ps=0.995 w=0.64 l=0.15
X36 VDPWR halfP/xq3.A a_26201_41873# VDPWR sky130_fd_pr__pfet_01v8_hvt ad=0.135 pd=1.27 as=0.135 ps=1.27 w=1 l=0.15
X37 a_3947_41457# a_3818_41201# a_3527_41311# VGND sky130_fd_pr__special_nfet_01v8 ad=0.0989 pd=0.995 as=0.0684 ps=0.74 w=0.36 l=0.15
X38 uo_out[7] a_14839_42711# VDPWR VDPWR sky130_fd_pr__pfet_01v8_hvt ad=0.135 pd=1.27 as=0.135 ps=1.27 w=1 l=0.15
X39 a_15189_41623# a_15023_41623# VGND VGND sky130_fd_pr__nfet_01v8 ad=0.1092 pd=1.36 as=0.0567 ps=0.69 w=0.42 l=0.15
X40 a_2829_40785# a_2799_40720# halfN/xq5.X VDPWR sky130_fd_pr__pfet_01v8_hvt ad=0.26 pd=2.52 as=0.3 ps=2.6 w=1 l=0.15
X41 VGND halfP/obuf3.A a_26119_40785# VGND sky130_fd_pr__nfet_01v8 ad=0.08775 pd=0.92 as=0.08775 ps=0.92 w=0.65 l=0.15
X42 a_16531_43255# a_15667_43261# a_16274_43229# VDPWR sky130_fd_pr__pfet_01v8_hvt ad=0.0567 pd=0.69 as=0.1095 ps=1.075 w=0.42 l=0.15
X43 a_12683_42685# a_12967_42685# a_12902_42711# VGND sky130_fd_pr__special_nfet_01v8 ad=0.0684 pd=0.74 as=0.066 ps=0.745 w=0.36 l=0.15
X44 a_6022_24748# a_6022_24748# VDPWR VDPWR sky130_fd_pr__pfet_01v8 ad=0.74 pd=4.37 as=0.74 ps=4.37 w=4 l=2
X45 halfN/RDA.R1_13 halfN/xq2.X VGND sky130_fd_pr__res_xhigh_po_0p35 l=30.3
X46 uo_out[5] a_16679_42167# VDPWR VDPWR sky130_fd_pr__pfet_01v8_hvt ad=0.135 pd=1.27 as=0.135 ps=1.27 w=1 l=0.15
X47 a_13450_42444# a_13250_42289# a_13599_42533# VGND sky130_fd_pr__special_nfet_01v8 ad=0.0621 pd=0.705 as=0.0696 ps=0.765 w=0.36 l=0.15
X48 a_25204_40369# a_24805_39997# a_25078_39991# VGND sky130_fd_pr__special_nfet_01v8 ad=0.0696 pd=0.765 as=0.0621 ps=0.705 w=0.36 l=0.15
X49 a_18390_43229# a_18222_43255# VGND VGND sky130_fd_pr__nfet_01v8 ad=0.0989 pd=0.995 as=0.12095 ps=1.085 w=0.64 l=0.15
X50 VDPWR a_25503_43255# a_25671_43229# VDPWR sky130_fd_pr__pfet_01v8_hvt ad=0.135 pd=1.27 as=0.27 ps=2.54 w=1 l=0.15
X51 a_3527_43487# a_3818_43377# a_3769_43255# VDPWR sky130_fd_pr__pfet_01v8_hvt ad=0.0567 pd=0.69 as=0.0882 ps=0.84 w=0.42 l=0.15
X52 VGND a_25503_43255# a_25671_43229# VGND sky130_fd_pr__nfet_01v8 ad=0.08775 pd=0.92 as=0.169 ps=1.82 w=0.65 l=0.15
X53 VGND a_12587_42863# halfN/obuf6.A VGND sky130_fd_pr__nfet_01v8 ad=0.08775 pd=0.92 as=0.169 ps=1.82 w=0.65 l=0.15
X54 a_15561_42167# halfP/dff2.D VDPWR VDPWR sky130_fd_pr__pfet_01v8_hvt ad=0.05775 pd=0.695 as=0.1092 ps=1.36 w=0.42 l=0.15
X55 halfP/xq2.A a_18171_41891# VGND VGND sky130_fd_pr__nfet_01v8 ad=0.169 pd=1.82 as=0.08775 ps=0.92 w=0.65 l=0.15
X56 a_24993_42167# halfP/xq2.A VGND VGND sky130_fd_pr__nfet_01v8 ad=0.0813 pd=0.83 as=0.1092 ps=1.36 w=0.42 l=0.15
X57 VGND halfN/obuf5.A a_4365_40369# VGND sky130_fd_pr__nfet_01v8 ad=0.1092 pd=1.36 as=0.0813 ps=0.83 w=0.42 l=0.15
X58 a_2829_43255# halfN/xq0.B VDPWR VDPWR sky130_fd_pr__pfet_01v8_hvt ad=0.135 pd=1.27 as=0.26 ps=2.52 w=1 l=0.15
X59 a_11694_41989# a_11447_41623# VDPWR VDPWR sky130_fd_pr__pfet_01v8_hvt ad=0.07665 pd=0.785 as=0.17887 ps=1.26 w=0.42 l=0.15
X60 uio_out[2] a_12343_42141# VGND VGND sky130_fd_pr__nfet_01v8 ad=0.08775 pd=0.92 as=0.169 ps=1.82 w=0.65 l=0.15
X61 VDPWR a_18187_42167# a_18355_42141# VDPWR sky130_fd_pr__pfet_01v8_hvt ad=0.135 pd=1.27 as=0.27 ps=2.54 w=1 l=0.15
X62 halfP/CM1.C2 a_24310_24722# VGND VGND sky130_fd_pr__nfet_01v8 ad=0.555 pd=3.37 as=0.99 ps=6.66 w=3 l=0.5
X63 halfP/xq6.X halfP/xq6.B a_26369_40311# VGND sky130_fd_pr__nfet_01v8 ad=0.25025 pd=1.42 as=0.08775 ps=0.92 w=0.65 l=0.15
X64 VDPWR a_3431_43487# halfN/xq0.B VDPWR sky130_fd_pr__pfet_01v8_hvt ad=0.135 pd=1.27 as=0.26 ps=2.52 w=1 l=0.15
X65 a_25503_43255# a_24639_43261# a_25246_43229# VDPWR sky130_fd_pr__pfet_01v8_hvt ad=0.0567 pd=0.69 as=0.1095 ps=1.075 w=0.42 l=0.15
X66 VGND a_18187_42167# a_18355_42141# VGND sky130_fd_pr__nfet_01v8 ad=0.08775 pd=0.92 as=0.169 ps=1.82 w=0.65 l=0.15
X67 a_25173_43255# a_24639_43261# a_25078_43255# VDPWR sky130_fd_pr__pfet_01v8_hvt ad=0.07665 pd=0.785 as=0.06825 ps=0.745 w=0.42 l=0.15
X68 VGND a_12343_42141# uio_out[2] VGND sky130_fd_pr__nfet_01v8 ad=0.08775 pd=0.92 as=0.08775 ps=0.92 w=0.65 l=0.15
X69 VDPWR clk a_24639_42173# VDPWR sky130_fd_pr__pfet_01v8_hvt ad=0.0864 pd=0.91 as=0.1664 ps=1.8 w=0.64 l=0.15
X70 a_3811_41297# clk VDPWR VDPWR sky130_fd_pr__pfet_01v8_hvt ad=0.1664 pd=1.8 as=0.0864 ps=0.91 w=0.64 l=0.15
X71 VGND halfP/xq2.A a_18611_41623# VGND sky130_fd_pr__nfet_01v8 ad=0.08775 pd=0.92 as=0.169 ps=1.82 w=0.65 l=0.15
X72 uo_out[7] a_14839_42711# VDPWR VDPWR sky130_fd_pr__pfet_01v8_hvt ad=0.135 pd=1.27 as=0.135 ps=1.27 w=1 l=0.15
X73 a_18187_42167# a_17323_42173# a_17930_42141# VDPWR sky130_fd_pr__pfet_01v8_hvt ad=0.0567 pd=0.69 as=0.1095 ps=1.075 w=0.42 l=0.15
X74 a_11518_41597# a_11311_41597# a_11694_41989# VDPWR sky130_fd_pr__pfet_01v8_hvt ad=0.06825 pd=0.745 as=0.07665 ps=0.785 w=0.42 l=0.15
X75 uio_out[1] a_12527_41597# VGND VGND sky130_fd_pr__nfet_01v8 ad=0.08775 pd=0.92 as=0.169 ps=1.82 w=0.65 l=0.15
X76 VGND a_24310_24722# halfP/CM1.C2 VGND sky130_fd_pr__nfet_01v8 ad=0.99 pd=6.66 as=0.555 ps=3.37 w=3 l=0.5
X77 halfN/RIN.R2_1 halfN/CM1.C2 sky130_fd_pr__cap_mim_m3_1 l=25 w=24
X78 a_17086_39596# a_15306_39570# VDPWR VDPWR sky130_fd_pr__pfet_01v8 ad=0.15 pd=1.3 as=0.33 ps=2.66 w=1 l=1
X79 a_11447_41623# a_11311_41597# a_11027_41597# VDPWR sky130_fd_pr__pfet_01v8_hvt ad=0.1095 pd=1.075 as=0.0567 ps=0.69 w=0.42 l=0.15
X80 a_25078_41989# a_24639_41623# a_24993_41623# VGND sky130_fd_pr__special_nfet_01v8 ad=0.0621 pd=0.705 as=0.0813 ps=0.83 w=0.36 l=0.15
X81 VDPWR uio_oe[2] sky130_fd_pr__res_generic_po w=0.48 l=0.5
X82 VGND a_12527_41597# uio_out[1] VGND sky130_fd_pr__nfet_01v8 ad=0.08775 pd=0.92 as=0.08775 ps=0.92 w=0.65 l=0.15
X83 VDPWR a_25246_43229# a_25173_43255# VDPWR sky130_fd_pr__pfet_01v8_hvt ad=0.17887 pd=1.26 as=0.07665 ps=0.785 w=0.42 l=0.15
X84 a_3431_41775# a_3527_41597# VGND VGND sky130_fd_pr__nfet_01v8 ad=0.169 pd=1.82 as=0.08775 ps=0.92 w=0.65 l=0.15
X85 a_9894_39236# halfN/dff3.D halfN/dff5.D VGND sky130_fd_pr__nfet_01v8 ad=0.075 pd=0.8 as=0.165 ps=1.66 w=0.5 l=0.15
X86 halfP/RIN.R1_0 halfP/RIN.R2_1 VGND sky130_fd_pr__res_xhigh_po_0p35 l=4.3
X87 uio_oe[3] VDPWR sky130_fd_pr__res_generic_po w=0.48 l=0.5
X88 a_15971_41989# a_15189_41623# a_15887_41989# VDPWR sky130_fd_pr__pfet_01v8_hvt ad=0.0882 pd=0.84 as=0.0567 ps=0.69 w=0.42 l=0.15
X89 VGND a_16347_43077# a_16515_42979# VGND sky130_fd_pr__nfet_01v8 ad=0.08775 pd=0.92 as=0.169 ps=1.82 w=0.65 l=0.15
X90 VDPWR a_12863_42399# halfN/xq3.A VDPWR sky130_fd_pr__pfet_01v8_hvt ad=0.135 pd=1.27 as=0.26 ps=2.52 w=1 l=0.15
X91 VDPWR clk a_17139_41623# VDPWR sky130_fd_pr__pfet_01v8_hvt ad=0.0864 pd=0.91 as=0.1664 ps=1.8 w=0.64 l=0.15
X92 VDPWR a_6022_24748# halfN/CM1.C2 VDPWR sky130_fd_pr__pfet_01v8 ad=0.74 pd=4.37 as=0.74 ps=4.37 w=4 l=2
X93 a_24993_41623# halfP/xq3.A VGND VGND sky130_fd_pr__nfet_01v8 ad=0.0813 pd=0.83 as=0.1092 ps=1.36 w=0.42 l=0.15
X94 a_25246_41053# a_25078_41079# VDPWR VDPWR sky130_fd_pr__pfet_01v8_hvt ad=0.1095 pd=1.075 as=0.17887 ps=1.26 w=0.75 l=0.15
X95 a_17026_24748# RBT.R2_0 a_19300_24748# VGND sky130_fd_pr__nfet_01v8 ad=2.22 pd=12.37 as=2.22 ps=12.37 w=12 l=3
X96 a_3185_43255# halfN/xq0.A VDPWR VDPWR sky130_fd_pr__pfet_01v8_hvt ad=0.135 pd=1.27 as=0.135 ps=1.27 w=1 l=0.15
X97 a_11221_43633# a_10674_43377# a_10874_43532# VDPWR sky130_fd_pr__pfet_01v8_hvt ad=0.05775 pd=0.695 as=0.06825 ps=0.745 w=0.42 l=0.15
X98 a_3017_41399# halfN/xq4.B halfN/xq4.X VGND sky130_fd_pr__nfet_01v8 ad=0.08775 pd=0.92 as=0.25025 ps=1.42 w=0.65 l=0.15
X99 a_25078_41079# a_24805_41085# a_24993_41079# VDPWR sky130_fd_pr__pfet_01v8_hvt ad=0.06825 pd=0.745 as=0.05775 ps=0.695 w=0.42 l=0.15
X100 a_16473_42711# a_15483_42711# a_16347_43077# VGND sky130_fd_pr__special_nfet_01v8 ad=0.066 pd=0.745 as=0.0684 ps=0.74 w=0.36 l=0.15
X101 a_24805_41623# a_24639_41623# VDPWR VDPWR sky130_fd_pr__pfet_01v8_hvt ad=0.1664 pd=1.8 as=0.0864 ps=0.91 w=0.64 l=0.15
X102 VGND halfN/xq6.B a_2799_39965# VGND sky130_fd_pr__nfet_01v8 ad=0.169 pd=1.82 as=0.08775 ps=0.92 w=0.65 l=0.15
X103 halfN/xq6.X a_2799_39965# VGND VGND sky130_fd_pr__nfet_01v8 ad=0.25025 pd=1.42 as=0.208 ps=1.94 w=0.65 l=0.15
X104 a_13323_42711# a_13103_42711# VGND VGND sky130_fd_pr__nfet_01v8 ad=0.0696 pd=0.765 as=0.12095 ps=1.085 w=0.42 l=0.15
X105 a_6022_24748# a_6022_24748# VDPWR VDPWR sky130_fd_pr__pfet_01v8 ad=0.74 pd=4.37 as=1.32 ps=8.66 w=4 l=2
X106 halfN/RDA.R1_1 halfN/RDA.R2_2 VGND sky130_fd_pr__res_xhigh_po_0p35 l=30.3
X107 halfN/RDA.R1_37 halfN/xq6.X VGND sky130_fd_pr__res_xhigh_po_0p35 l=30.3
X108 VGND halfN/dff3.D a_11681_42545# VGND sky130_fd_pr__nfet_01v8 ad=0.1092 pd=1.36 as=0.0813 ps=0.83 w=0.42 l=0.15
X109 a_25503_43077# a_24805_42711# a_25246_42823# VGND sky130_fd_pr__special_nfet_01v8 ad=0.0684 pd=0.74 as=0.0989 ps=0.995 w=0.36 l=0.15
X110 VGND a_10411_41597# uio_out[5] VGND sky130_fd_pr__nfet_01v8 ad=0.08775 pd=0.92 as=0.08775 ps=0.92 w=0.65 l=0.15
X111 VGND RARR.R2_2 VGND sky130_fd_pr__res_xhigh_po_0p35 l=20
X112 halfN/RDA.R1_37 halfN/RDA.R2_38 VGND sky130_fd_pr__res_xhigh_po_0p35 l=30.3
X113 VDPWR halfN/xq1.A a_2829_42961# VDPWR sky130_fd_pr__pfet_01v8_hvt ad=0.135 pd=1.27 as=0.135 ps=1.27 w=1 l=0.15
X114 VDPWR halfN/dff6.D a_13521_42711# VDPWR sky130_fd_pr__pfet_01v8_hvt ad=0.1092 pd=1.36 as=0.05775 ps=0.695 w=0.42 l=0.15
X115 VDPWR a_13634_41597# a_13563_41623# VDPWR sky130_fd_pr__pfet_01v8_hvt ad=0.17887 pd=1.26 as=0.1095 ps=1.075 w=0.75 l=0.15
X116 a_17746_41735# a_17578_41989# VDPWR VDPWR sky130_fd_pr__pfet_01v8_hvt ad=0.1095 pd=1.075 as=0.17887 ps=1.26 w=0.75 l=0.15
X117 VDPWR halfP/xq0.A a_26201_43255# VDPWR sky130_fd_pr__pfet_01v8_hvt ad=0.135 pd=1.27 as=0.135 ps=1.27 w=1 l=0.15
X118 VGND halfN/xq3.A a_3017_41623# VGND sky130_fd_pr__nfet_01v8 ad=0.08775 pd=0.92 as=0.08775 ps=0.92 w=0.65 l=0.15
X119 a_24805_40535# a_24639_40535# VDPWR VDPWR sky130_fd_pr__pfet_01v8_hvt ad=0.1664 pd=1.8 as=0.0864 ps=0.91 w=0.64 l=0.15
X120 a_18773_43633# a_17783_43261# a_18647_43255# VGND sky130_fd_pr__special_nfet_01v8 ad=0.066 pd=0.745 as=0.0684 ps=0.74 w=0.36 l=0.15
X121 a_12587_42863# a_12683_42685# VDPWR VDPWR sky130_fd_pr__pfet_01v8_hvt ad=0.27 pd=2.54 as=0.135 ps=1.27 w=1 l=0.15
X122 a_24805_41085# a_24639_41085# VGND VGND sky130_fd_pr__nfet_01v8 ad=0.1092 pd=1.36 as=0.0567 ps=0.69 w=0.42 l=0.15
X123 a_26369_40311# halfP/obuf5.A VGND VGND sky130_fd_pr__nfet_01v8 ad=0.08775 pd=0.92 as=0.08775 ps=0.92 w=0.65 l=0.15
X124 a_24805_39997# a_24639_39997# VDPWR VDPWR sky130_fd_pr__pfet_01v8_hvt ad=0.1664 pd=1.8 as=0.0864 ps=0.91 w=0.64 l=0.15
X125 VGND a_18795_42167# uo_out[1] VGND sky130_fd_pr__nfet_01v8 ad=0.169 pd=1.82 as=0.08775 ps=0.92 w=0.65 l=0.15
X126 halfP/xq6.B a_25671_39965# VDPWR VDPWR sky130_fd_pr__pfet_01v8_hvt ad=0.26 pd=2.52 as=0.135 ps=1.27 w=1 l=0.15
X127 a_3947_40369# a_3811_40209# a_3527_40223# VDPWR sky130_fd_pr__pfet_01v8_hvt ad=0.1095 pd=1.075 as=0.0567 ps=0.69 w=0.42 l=0.15
X128 VGND a_9767_43229# uio_out[7] VGND sky130_fd_pr__nfet_01v8 ad=0.08775 pd=0.92 as=0.08775 ps=0.92 w=0.65 l=0.15
X129 a_2829_42167# a_2799_42141# halfN/xq2.X VDPWR sky130_fd_pr__pfet_01v8_hvt ad=0.26 pd=2.52 as=0.3 ps=2.6 w=1 l=0.15
X130 a_18003_41989# a_17305_41623# a_17746_41735# VGND sky130_fd_pr__special_nfet_01v8 ad=0.0684 pd=0.74 as=0.0989 ps=0.995 w=0.36 l=0.15
X131 VDPWR halfP/xq6.B a_26369_39991# VDPWR sky130_fd_pr__pfet_01v8_hvt ad=0.26 pd=2.52 as=0.135 ps=1.27 w=1 l=0.15
X132 a_9894_39596# halfN/dff3.D halfN/dff5.D VDPWR sky130_fd_pr__pfet_01v8 ad=0.15 pd=1.3 as=0.33 ps=2.66 w=1 l=0.15
X133 a_18129_41623# a_17139_41623# a_18003_41989# VGND sky130_fd_pr__special_nfet_01v8 ad=0.066 pd=0.745 as=0.0684 ps=0.74 w=0.36 l=0.15
X134 a_3746_41445# a_3431_41311# VGND VGND sky130_fd_pr__nfet_01v8 ad=0.066 pd=0.745 as=0.1092 ps=1.36 w=0.42 l=0.15
X135 uio_out[0] a_14183_42685# VDPWR VDPWR sky130_fd_pr__pfet_01v8_hvt ad=0.135 pd=1.27 as=0.26 ps=2.52 w=1 l=0.15
X136 a_26201_42961# halfP/xq1.B a_26119_42961# VDPWR sky130_fd_pr__pfet_01v8_hvt ad=0.135 pd=1.27 as=0.26 ps=2.52 w=1 l=0.15
X137 VDPWR halfN/xq1.A a_4365_42711# VDPWR sky130_fd_pr__pfet_01v8_hvt ad=0.1092 pd=1.36 as=0.05775 ps=0.695 w=0.42 l=0.15
X138 VDPWR a_14839_42711# uo_out[7] VDPWR sky130_fd_pr__pfet_01v8_hvt ad=0.135 pd=1.27 as=0.135 ps=1.27 w=1 l=0.15
X139 a_13047_41775# a_13143_41597# VGND VGND sky130_fd_pr__nfet_01v8 ad=0.169 pd=1.82 as=0.08775 ps=0.92 w=0.65 l=0.15
X140 uo_out[2] a_18611_41623# VDPWR VDPWR sky130_fd_pr__pfet_01v8_hvt ad=0.135 pd=1.27 as=0.135 ps=1.27 w=1 l=0.15
X141 a_25587_39991# a_24805_39997# a_25503_39991# VDPWR sky130_fd_pr__pfet_01v8_hvt ad=0.0882 pd=0.84 as=0.0567 ps=0.69 w=0.42 l=0.15
X142 a_3431_40223# a_3527_40223# VDPWR VDPWR sky130_fd_pr__pfet_01v8_hvt ad=0.27 pd=2.54 as=0.135 ps=1.27 w=1 l=0.15
X143 halfP/xq1.X a_26119_42961# a_26369_42961# VDPWR sky130_fd_pr__pfet_01v8_hvt ad=0.3 pd=2.6 as=0.26 ps=2.52 w=1 l=0.15
X144 a_2799_41053# halfN/obuf6.A VGND VGND sky130_fd_pr__nfet_01v8 ad=0.08775 pd=0.92 as=0.08775 ps=0.92 w=0.65 l=0.15
X145 halfN/RDA.R1_11 halfN/RIN.R2_1 VGND sky130_fd_pr__res_xhigh_po_0p35 l=30.3
X146 a_4194_43255# a_3947_43633# VDPWR VDPWR sky130_fd_pr__pfet_01v8_hvt ad=0.07665 pd=0.785 as=0.17887 ps=1.26 w=0.42 l=0.15
X147 a_12067_42685# halfN/obuf6.A VGND VGND sky130_fd_pr__nfet_01v8 ad=0.169 pd=1.82 as=0.08775 ps=0.92 w=0.65 l=0.15
X148 a_26119_41873# halfP/xq3.B VGND VGND sky130_fd_pr__nfet_01v8 ad=0.08775 pd=0.92 as=0.169 ps=1.82 w=0.65 l=0.15
X149 a_25078_41079# a_24639_41085# a_24993_41079# VGND sky130_fd_pr__special_nfet_01v8 ad=0.0621 pd=0.705 as=0.0813 ps=0.83 w=0.36 l=0.15
X150 a_4018_40509# a_3818_40809# a_4167_40535# VGND sky130_fd_pr__special_nfet_01v8 ad=0.0621 pd=0.705 as=0.0696 ps=0.765 w=0.36 l=0.15
X151 tie_oe6.LO VGND sky130_fd_pr__res_generic_po w=0.48 l=0.5
X152 halfN/RDA.R1_33 halfN/RDA.R2_34 VGND sky130_fd_pr__res_xhigh_po_0p35 l=30.3
X153 VGND halfP/mon.A a_14839_42711# VGND sky130_fd_pr__nfet_01v8 ad=0.08775 pd=0.92 as=0.169 ps=1.82 w=0.65 l=0.15
X154 VGND halfP/dff5.D VGND VGND sky130_fd_pr__nfet_01v8 ad=0.49 pd=3.5 as=67.8548 ps=621.91998 w=1.4 l=2.86
X155 a_15887_41989# a_15023_41623# a_15630_41735# VDPWR sky130_fd_pr__pfet_01v8_hvt ad=0.0567 pd=0.69 as=0.1095 ps=1.075 w=0.42 l=0.15
X156 RBT.R1_2 RBT.R2_1 VGND sky130_fd_pr__res_xhigh_po_0p35 l=4.38
X157 a_12403_43487# a_12499_43487# VDPWR VDPWR sky130_fd_pr__pfet_01v8_hvt ad=0.27 pd=2.54 as=0.135 ps=1.27 w=1 l=0.15
X158 VGND a_16955_42711# uo_out[4] VGND sky130_fd_pr__nfet_01v8 ad=0.169 pd=1.82 as=0.08775 ps=0.92 w=0.65 l=0.15
X159 a_15557_41989# a_15023_41623# a_15462_41989# VDPWR sky130_fd_pr__pfet_01v8_hvt ad=0.07665 pd=0.785 as=0.06825 ps=0.745 w=0.42 l=0.15
X160 VGND VGND VGND sky130_fd_pr__res_xhigh_po_0p35 l=20
X161 halfN/RDA.R1_35 halfN/RDA.R2_34 VGND sky130_fd_pr__res_xhigh_po_0p35 l=30.3
X162 a_4018_43532# a_3811_43473# a_4194_43255# VDPWR sky130_fd_pr__pfet_01v8_hvt ad=0.06825 pd=0.745 as=0.07665 ps=0.785 w=0.42 l=0.15
X163 RBT.R1_0 RBT.R2_1 VGND sky130_fd_pr__res_xhigh_po_0p35 l=4.38
X164 a_15306_39570# halfP/CM1.C2 RARR.R1_3 VGND sky130_fd_pr__nfet_01v8 ad=1.32 pd=8.66 as=1.32 ps=8.66 w=4 l=1
X165 VGND a_11883_43229# uio_out[4] VGND sky130_fd_pr__nfet_01v8 ad=0.08775 pd=0.92 as=0.08775 ps=0.92 w=0.65 l=0.15
X166 halfP/RDA.R1_9 halfP/RDA.R2_8 VGND sky130_fd_pr__res_xhigh_po_0p35 l=30.3
X167 a_4167_42533# a_3947_42545# VGND VGND sky130_fd_pr__nfet_01v8 ad=0.0696 pd=0.765 as=0.12095 ps=1.085 w=0.42 l=0.15
X168 VGND halfP/obuf6.A a_26119_41079# VGND sky130_fd_pr__nfet_01v8 ad=0.08775 pd=0.92 as=0.08775 ps=0.92 w=0.65 l=0.15
X169 a_11334_39236# halfN/dff1.D halfN/dff2.D VGND sky130_fd_pr__nfet_01v8 ad=0.075 pd=0.8 as=0.165 ps=1.66 w=0.5 l=0.15
X170 uo_out[3] a_17139_43255# VGND VGND sky130_fd_pr__nfet_01v8 ad=0.08775 pd=0.92 as=0.08775 ps=0.92 w=0.65 l=0.15
X171 a_25246_42823# a_25078_43077# VDPWR VDPWR sky130_fd_pr__pfet_01v8_hvt ad=0.1095 pd=1.075 as=0.17887 ps=1.26 w=0.75 l=0.15
X172 VGND a_25246_41053# a_25204_41457# VGND sky130_fd_pr__nfet_01v8 ad=0.12095 pd=1.085 as=0.0696 ps=0.765 w=0.42 l=0.15
X173 a_13626_42167# a_13379_42545# VDPWR VDPWR sky130_fd_pr__pfet_01v8_hvt ad=0.07665 pd=0.785 as=0.17887 ps=1.26 w=0.42 l=0.15
X174 a_15786_39096# a_15786_39096# VGND VGND sky130_fd_pr__nfet_01v8 ad=0.165 pd=1.66 as=0.165 ps=1.66 w=0.5 l=1
X175 a_24805_40535# a_24639_40535# VGND VGND sky130_fd_pr__nfet_01v8 ad=0.1092 pd=1.36 as=0.0567 ps=0.69 w=0.42 l=0.15
X176 a_5130_26120# RB.R2_1 a_3464_26480# VGND sky130_fd_pr__nfet_01v8 ad=0.1386 pd=1.5 as=0.1386 ps=1.5 w=0.42 l=8
X177 a_3527_42685# a_3811_42685# a_3746_42711# VGND sky130_fd_pr__special_nfet_01v8 ad=0.0684 pd=0.74 as=0.066 ps=0.745 w=0.36 l=0.15
X178 VDPWR a_3811_42385# a_3818_42289# VDPWR sky130_fd_pr__pfet_01v8_hvt ad=0.0864 pd=0.91 as=0.1664 ps=1.8 w=0.64 l=0.15
X179 uo_out[6] a_16495_41623# VDPWR VDPWR sky130_fd_pr__pfet_01v8_hvt ad=0.135 pd=1.27 as=0.135 ps=1.27 w=1 l=0.15
X180 a_2799_39965# halfN/xq6.B a_3185_39991# VDPWR sky130_fd_pr__pfet_01v8_hvt ad=0.26 pd=2.52 as=0.135 ps=1.27 w=1 l=0.15
X181 a_3746_40535# a_3431_40687# VGND VGND sky130_fd_pr__nfet_01v8 ad=0.066 pd=0.745 as=0.1092 ps=1.36 w=0.42 l=0.15
X182 halfP/xq1.B a_25671_42979# VGND VGND sky130_fd_pr__nfet_01v8 ad=0.169 pd=1.82 as=0.08775 ps=0.92 w=0.65 l=0.15
X183 a_12990_43532# a_12790_43377# a_13139_43621# VGND sky130_fd_pr__special_nfet_01v8 ad=0.0621 pd=0.705 as=0.0696 ps=0.765 w=0.36 l=0.15
X184 a_13450_42444# a_13243_42385# a_13626_42167# VDPWR sky130_fd_pr__pfet_01v8_hvt ad=0.06825 pd=0.745 as=0.07665 ps=0.785 w=0.42 l=0.15
X185 a_10411_41597# halfN/xq2.A VDPWR VDPWR sky130_fd_pr__pfet_01v8_hvt ad=0.26 pd=2.52 as=0.135 ps=1.27 w=1 l=0.15
X186 VDPWR a_16495_41623# uo_out[6] VDPWR sky130_fd_pr__pfet_01v8_hvt ad=0.26 pd=2.52 as=0.135 ps=1.27 w=1 l=0.15
X187 VDPWR clk a_17783_43261# VDPWR sky130_fd_pr__pfet_01v8_hvt ad=0.0864 pd=0.91 as=0.1664 ps=1.8 w=0.64 l=0.15
X188 tie_oe0.LO VGND sky130_fd_pr__res_generic_po w=0.48 l=0.5
X189 a_12967_42685# clk VDPWR VDPWR sky130_fd_pr__pfet_01v8_hvt ad=0.1664 pd=1.8 as=0.0864 ps=0.91 w=0.64 l=0.15
X190 VDPWR halfN/xq2.A a_4365_42545# VDPWR sky130_fd_pr__pfet_01v8_hvt ad=0.1092 pd=1.36 as=0.05775 ps=0.695 w=0.42 l=0.15
X191 a_13379_42545# a_13243_42385# a_12959_42399# VDPWR sky130_fd_pr__pfet_01v8_hvt ad=0.1095 pd=1.075 as=0.0567 ps=0.69 w=0.42 l=0.15
X192 a_25503_42167# a_24805_42173# a_25246_42141# VGND sky130_fd_pr__special_nfet_01v8 ad=0.0684 pd=0.74 as=0.0989 ps=0.995 w=0.36 l=0.15
X193 VGND a_12990_43532# a_12919_43633# VGND sky130_fd_pr__nfet_01v8 ad=0.12095 pd=1.085 as=0.0989 ps=0.995 w=0.64 l=0.15
X194 a_12925_43077# a_12587_42863# VDPWR VDPWR sky130_fd_pr__pfet_01v8_hvt ad=0.0882 pd=0.84 as=0.1113 ps=1.37 w=0.42 l=0.15
X195 VDPWR a_25671_42979# a_25587_43077# VDPWR sky130_fd_pr__pfet_01v8_hvt ad=0.1113 pd=1.37 as=0.0882 ps=0.84 w=0.42 l=0.15
X196 halfN/RDA.R1_17 halfN/RDA.R2_16 VGND sky130_fd_pr__res_xhigh_po_0p35 l=30.3
X197 VGND a_3431_42863# halfN/xq1.B VGND sky130_fd_pr__nfet_01v8 ad=0.08775 pd=0.92 as=0.169 ps=1.82 w=0.65 l=0.15
X198 VDPWR a_18003_41989# a_18171_41891# VDPWR sky130_fd_pr__pfet_01v8_hvt ad=0.135 pd=1.27 as=0.27 ps=2.54 w=1 l=0.15
X199 halfP/RDA.R1_13 halfP/xq2.X VGND sky130_fd_pr__res_xhigh_po_0p35 l=30.3
X200 a_13143_41597# a_13427_41597# a_13362_41623# VGND sky130_fd_pr__special_nfet_01v8 ad=0.0684 pd=0.74 as=0.066 ps=0.745 w=0.36 l=0.15
X201 halfP/RDA.R1_21 halfP/RDA.R2_20 VGND sky130_fd_pr__res_xhigh_po_0p35 l=30.3
X202 a_12783_43473# clk VDPWR VDPWR sky130_fd_pr__pfet_01v8_hvt ad=0.1664 pd=1.8 as=0.0864 ps=0.91 w=0.64 l=0.15
X203 uo_out[1] a_18795_42167# VGND VGND sky130_fd_pr__nfet_01v8 ad=0.08775 pd=0.92 as=0.08775 ps=0.92 w=0.65 l=0.15
X204 VGND a_26119_39991# halfP/xq6.X VGND sky130_fd_pr__nfet_01v8 ad=0.208 pd=1.94 as=0.25025 ps=1.42 w=0.65 l=0.15
X205 VGND a_4018_40509# a_3947_40535# VGND sky130_fd_pr__nfet_01v8 ad=0.12095 pd=1.085 as=0.0989 ps=0.995 w=0.64 l=0.15
X206 uio_out[7] a_9767_43229# VGND VGND sky130_fd_pr__nfet_01v8 ad=0.08775 pd=0.92 as=0.169 ps=1.82 w=0.65 l=0.15
X207 VDPWR a_19255_43255# uo_out[0] VDPWR sky130_fd_pr__pfet_01v8_hvt ad=0.135 pd=1.27 as=0.135 ps=1.27 w=1 l=0.15
X208 halfP/RDA.R1_11 halfP/RIN.R2_1 VGND sky130_fd_pr__res_xhigh_po_0p35 l=30.3
X209 a_26369_39991# halfP/obuf5.A VDPWR VDPWR sky130_fd_pr__pfet_01v8_hvt ad=0.135 pd=1.27 as=0.135 ps=1.27 w=1 l=0.15
X210 VGND a_11883_43229# uio_out[4] VGND sky130_fd_pr__nfet_01v8 ad=0.08775 pd=0.92 as=0.08775 ps=0.92 w=0.65 l=0.15
X211 halfP/RDA.R1_19 halfP/RDA.R2_20 VGND sky130_fd_pr__res_xhigh_po_0p35 l=30.3
X212 a_3431_42399# a_3527_42399# VGND VGND sky130_fd_pr__nfet_01v8 ad=0.169 pd=1.82 as=0.08775 ps=0.92 w=0.65 l=0.15
X213 a_4167_41623# a_3947_41623# VGND VGND sky130_fd_pr__nfet_01v8 ad=0.0696 pd=0.765 as=0.12095 ps=1.085 w=0.42 l=0.15
X214 VGND a_13047_41775# halfN/xq0.A VGND sky130_fd_pr__nfet_01v8 ad=0.08775 pd=0.92 as=0.169 ps=1.82 w=0.65 l=0.15
X215 a_12499_43487# a_12790_43377# a_12741_43255# VDPWR sky130_fd_pr__pfet_01v8_hvt ad=0.0567 pd=0.69 as=0.0882 ps=0.84 w=0.42 l=0.15
X216 a_3527_40509# a_3818_40809# a_3769_40901# VDPWR sky130_fd_pr__pfet_01v8_hvt ad=0.0567 pd=0.69 as=0.0882 ps=0.84 w=0.42 l=0.15
X217 halfP/dff3.D halfP/dff6.D a_19006_39236# VGND sky130_fd_pr__nfet_01v8 ad=0.165 pd=1.66 as=0.075 ps=0.8 w=0.5 l=0.15
X218 VGND a_25246_40647# a_25204_40535# VGND sky130_fd_pr__nfet_01v8 ad=0.12095 pd=1.085 as=0.0696 ps=0.765 w=0.42 l=0.15
X219 VGND a_12067_42685# uio_out[3] VGND sky130_fd_pr__nfet_01v8 ad=0.08775 pd=0.92 as=0.08775 ps=0.92 w=0.65 l=0.15
X220 halfP/xq3.B a_25671_41891# VDPWR VDPWR sky130_fd_pr__pfet_01v8_hvt ad=0.26 pd=2.52 as=0.135 ps=1.27 w=1 l=0.15
X221 VGND halfP/dff6.D VGND VGND sky130_fd_pr__nfet_01v8 ad=0.49 pd=3.5 as=0 ps=0 w=1.4 l=2.86
X222 a_11334_39596# halfN/dff1.D halfN/dff2.D VDPWR sky130_fd_pr__pfet_01v8 ad=0.15 pd=1.3 as=0.33 ps=2.66 w=1 l=0.15
X223 VGND halfP/obuf6.A a_16955_42711# VGND sky130_fd_pr__nfet_01v8 ad=0.08775 pd=0.92 as=0.169 ps=1.82 w=0.65 l=0.15
X224 a_3811_41597# clk VDPWR VDPWR sky130_fd_pr__pfet_01v8_hvt ad=0.1664 pd=1.8 as=0.0864 ps=0.91 w=0.64 l=0.15
X225 VDPWR halfP/xq3.B a_26369_41873# VDPWR sky130_fd_pr__pfet_01v8_hvt ad=0.26 pd=2.52 as=0.135 ps=1.27 w=1 l=0.15
X226 a_4018_40268# a_3818_40113# a_4167_40357# VGND sky130_fd_pr__special_nfet_01v8 ad=0.0621 pd=0.705 as=0.0696 ps=0.765 w=0.36 l=0.15
X227 a_17857_42167# a_17323_42173# a_17762_42167# VDPWR sky130_fd_pr__pfet_01v8_hvt ad=0.07665 pd=0.785 as=0.06825 ps=0.745 w=0.42 l=0.15
X228 a_3769_41989# a_3431_41775# VDPWR VDPWR sky130_fd_pr__pfet_01v8_hvt ad=0.0882 pd=0.84 as=0.1113 ps=1.37 w=0.42 l=0.15
X229 VGND a_15630_41735# a_15588_41623# VGND sky130_fd_pr__nfet_01v8 ad=0.12095 pd=1.085 as=0.0696 ps=0.765 w=0.42 l=0.15
X230 a_25246_41735# a_25078_41989# VGND VGND sky130_fd_pr__nfet_01v8 ad=0.0989 pd=0.995 as=0.12095 ps=1.085 w=0.64 l=0.15
X231 a_15786_39096# a_15306_39570# VDPWR VDPWR sky130_fd_pr__pfet_01v8 ad=0.33 pd=2.66 as=0.33 ps=2.66 w=1 l=1
X232 a_25503_40901# a_24639_40535# a_25246_40647# VDPWR sky130_fd_pr__pfet_01v8_hvt ad=0.0567 pd=0.69 as=0.1095 ps=1.075 w=0.42 l=0.15
X233 VDPWR a_12403_43487# halfN/xq1.A VDPWR sky130_fd_pr__pfet_01v8_hvt ad=0.135 pd=1.27 as=0.26 ps=2.52 w=1 l=0.15
X234 uo_out[4] a_16955_42711# VGND VGND sky130_fd_pr__nfet_01v8 ad=0.08775 pd=0.92 as=0.08775 ps=0.92 w=0.65 l=0.15
X235 a_3431_41775# a_3527_41597# VDPWR VDPWR sky130_fd_pr__pfet_01v8_hvt ad=0.27 pd=2.54 as=0.135 ps=1.27 w=1 l=0.15
X236 halfP/xq5.X halfP/xq5.B a_26369_40535# VGND sky130_fd_pr__nfet_01v8 ad=0.25025 pd=1.42 as=0.08775 ps=0.92 w=0.65 l=0.15
X237 a_25173_40901# a_24639_40535# a_25078_40901# VDPWR sky130_fd_pr__pfet_01v8_hvt ad=0.07665 pd=0.785 as=0.06825 ps=0.745 w=0.42 l=0.15
X238 a_19300_24748# a_19300_24748# VDPWR VDPWR sky130_fd_pr__pfet_01v8 ad=0.74 pd=4.37 as=0.74 ps=4.37 w=4 l=2
X239 a_10374_39236# halfN/dff6.D halfN/dff3.D VGND sky130_fd_pr__nfet_01v8 ad=0.075 pd=0.8 as=0.165 ps=1.66 w=0.5 l=0.15
X240 VGND a_17139_43255# uo_out[3] VGND sky130_fd_pr__nfet_01v8 ad=0.08775 pd=0.92 as=0.08775 ps=0.92 w=0.65 l=0.15
X241 VDPWR a_25671_42141# a_25587_42167# VDPWR sky130_fd_pr__pfet_01v8_hvt ad=0.1113 pd=1.37 as=0.0882 ps=0.84 w=0.42 l=0.15
X242 a_15772_42545# a_15373_42173# a_15646_42167# VGND sky130_fd_pr__special_nfet_01v8 ad=0.0696 pd=0.765 as=0.0621 ps=0.705 w=0.36 l=0.15
X243 VGND clk a_24639_42173# VGND sky130_fd_pr__nfet_01v8 ad=0.0567 pd=0.69 as=0.1092 ps=1.36 w=0.42 l=0.15
X244 halfP/RDA.R1_37 halfP/RDA.R2_38 VGND sky130_fd_pr__res_xhigh_po_0p35 l=30.3
X245 halfP/RDA.R1_23 halfP/RIN.R2_1 VGND sky130_fd_pr__res_xhigh_po_0p35 l=30.3
X246 a_3811_40509# clk VDPWR VDPWR sky130_fd_pr__pfet_01v8_hvt ad=0.1664 pd=1.8 as=0.0864 ps=0.91 w=0.64 l=0.15
X247 VDPWR halfP/xq1.A a_17139_43255# VDPWR sky130_fd_pr__pfet_01v8_hvt ad=0.135 pd=1.27 as=0.26 ps=2.52 w=1 l=0.15
X248 a_3811_41297# clk VGND VGND sky130_fd_pr__nfet_01v8 ad=0.1092 pd=1.36 as=0.0567 ps=0.69 w=0.42 l=0.15
X249 a_3811_40209# clk VDPWR VDPWR sky130_fd_pr__pfet_01v8_hvt ad=0.1664 pd=1.8 as=0.0864 ps=0.91 w=0.64 l=0.15
X250 VDPWR a_25246_40647# a_25173_40901# VDPWR sky130_fd_pr__pfet_01v8_hvt ad=0.17887 pd=1.26 as=0.07665 ps=0.785 w=0.42 l=0.15
X251 a_11221_43633# a_10667_43473# a_10874_43532# VGND sky130_fd_pr__special_nfet_01v8 ad=0.0813 pd=0.83 as=0.0621 ps=0.705 w=0.36 l=0.15
X252 a_11865_41623# a_11311_41597# a_11518_41597# VGND sky130_fd_pr__special_nfet_01v8 ad=0.0813 pd=0.83 as=0.0621 ps=0.705 w=0.36 l=0.15
X253 VDPWR halfP/xq0.A a_16495_41623# VDPWR sky130_fd_pr__pfet_01v8_hvt ad=0.135 pd=1.27 as=0.26 ps=2.52 w=1 l=0.15
X254 VGND halfN/dff5.D a_11221_43633# VGND sky130_fd_pr__nfet_01v8 ad=0.1092 pd=1.36 as=0.0813 ps=0.83 w=0.42 l=0.15
X255 a_3527_42399# a_3811_42385# a_3746_42533# VGND sky130_fd_pr__special_nfet_01v8 ad=0.0684 pd=0.74 as=0.066 ps=0.745 w=0.36 l=0.15
X256 uio_out[2] a_12343_42141# VGND VGND sky130_fd_pr__nfet_01v8 ad=0.08775 pd=0.92 as=0.08775 ps=0.92 w=0.65 l=0.15
X257 VGND halfN/xq2.A a_3017_42487# VGND sky130_fd_pr__nfet_01v8 ad=0.08775 pd=0.92 as=0.08775 ps=0.92 w=0.65 l=0.15
X258 uo_out[6] a_16495_41623# VDPWR VDPWR sky130_fd_pr__pfet_01v8_hvt ad=0.135 pd=1.27 as=0.135 ps=1.27 w=1 l=0.15
X259 halfP/dff5.D halfP/dff3.D a_19486_39236# VGND sky130_fd_pr__nfet_01v8 ad=0.165 pd=1.66 as=0.075 ps=0.8 w=0.5 l=0.15
X260 a_10803_43633# a_10667_43473# a_10383_43487# VDPWR sky130_fd_pr__pfet_01v8_hvt ad=0.1095 pd=1.075 as=0.0567 ps=0.69 w=0.42 l=0.15
X261 VGND halfP/dff3.D VGND VGND sky130_fd_pr__nfet_01v8 ad=0.49 pd=3.5 as=0 ps=0 w=1.4 l=2.86
X262 a_18390_43229# a_18222_43255# VDPWR VDPWR sky130_fd_pr__pfet_01v8_hvt ad=0.1095 pd=1.075 as=0.17887 ps=1.26 w=0.75 l=0.15
X263 VGND a_18611_41623# uo_out[2] VGND sky130_fd_pr__nfet_01v8 ad=0.08775 pd=0.92 as=0.08775 ps=0.92 w=0.65 l=0.15
X264 VGND RB.R2_1 a_17026_24748# VGND sky130_fd_pr__nfet_01v8 ad=0.37 pd=2.37 as=0.37 ps=2.37 w=2 l=2
X265 a_2799_41808# halfN/xq3.B a_3185_41873# VDPWR sky130_fd_pr__pfet_01v8_hvt ad=0.26 pd=2.52 as=0.135 ps=1.27 w=1 l=0.15
X266 halfP/dff3.D halfP/dff6.D a_19006_39596# VDPWR sky130_fd_pr__pfet_01v8 ad=0.33 pd=2.66 as=0.15 ps=1.3 w=1 l=0.15
X267 a_25629_42711# a_24639_42711# a_25503_43077# VGND sky130_fd_pr__special_nfet_01v8 ad=0.066 pd=0.745 as=0.0684 ps=0.74 w=0.36 l=0.15
X268 a_10287_43487# a_10383_43487# VDPWR VDPWR sky130_fd_pr__pfet_01v8_hvt ad=0.27 pd=2.54 as=0.135 ps=1.27 w=1 l=0.15
X269 a_24993_41623# halfP/xq3.A VDPWR VDPWR sky130_fd_pr__pfet_01v8_hvt ad=0.05775 pd=0.695 as=0.1092 ps=1.36 w=0.42 l=0.15
X270 uo_out[1] a_18795_42167# VGND VGND sky130_fd_pr__nfet_01v8 ad=0.08775 pd=0.92 as=0.08775 ps=0.92 w=0.65 l=0.15
X271 a_10854_39236# halfN/dff2.D halfN/dff6.D VGND sky130_fd_pr__nfet_01v8 ad=0.075 pd=0.8 as=0.165 ps=1.66 w=0.5 l=0.15
X272 a_4365_42711# a_3818_42985# a_4018_42685# VDPWR sky130_fd_pr__pfet_01v8_hvt ad=0.05775 pd=0.695 as=0.06825 ps=0.745 w=0.42 l=0.15
X273 a_11334_42444# a_11134_42289# a_11483_42533# VGND sky130_fd_pr__special_nfet_01v8 ad=0.0621 pd=0.705 as=0.0696 ps=0.765 w=0.36 l=0.15
X274 VDPWR a_19300_24748# halfP/CM1.C2 VDPWR sky130_fd_pr__pfet_01v8 ad=0.74 pd=4.37 as=0.74 ps=4.37 w=4 l=2
X275 VGND halfN/xq5.B a_2799_40720# VGND sky130_fd_pr__nfet_01v8 ad=0.169 pd=1.82 as=0.08775 ps=0.92 w=0.65 l=0.15
X276 halfN/xq5.X a_2799_40720# VGND VGND sky130_fd_pr__nfet_01v8 ad=0.25025 pd=1.42 as=0.208 ps=1.94 w=0.65 l=0.15
X277 a_16274_43229# a_16106_43255# VGND VGND sky130_fd_pr__nfet_01v8 ad=0.0989 pd=0.995 as=0.12095 ps=1.085 w=0.64 l=0.15
X278 a_26119_42167# halfP/xq2.B VGND VGND sky130_fd_pr__nfet_01v8 ad=0.08775 pd=0.92 as=0.169 ps=1.82 w=0.65 l=0.15
X279 a_13427_41597# clk VDPWR VDPWR sky130_fd_pr__pfet_01v8_hvt ad=0.1664 pd=1.8 as=0.0864 ps=0.91 w=0.64 l=0.15
X280 halfP/xq0.A a_16055_41891# VGND VGND sky130_fd_pr__nfet_01v8 ad=0.169 pd=1.82 as=0.08775 ps=0.92 w=0.65 l=0.15
X281 halfP/RDA.R1_41 halfP/RDA.R2_40 VGND sky130_fd_pr__res_xhigh_po_0p35 l=30.3
X282 VGND a_9954_39096# a_9894_39236# VGND sky130_fd_pr__nfet_01v8 ad=0.165 pd=1.66 as=0.075 ps=0.8 w=0.5 l=1
X283 a_16347_43077# a_15649_42711# a_16090_42823# VGND sky130_fd_pr__special_nfet_01v8 ad=0.0684 pd=0.74 as=0.0989 ps=0.995 w=0.36 l=0.15
X284 VGND a_4018_42444# a_3947_42545# VGND sky130_fd_pr__nfet_01v8 ad=0.12095 pd=1.085 as=0.0989 ps=0.995 w=0.64 l=0.15
X285 a_13385_41989# a_13047_41775# VDPWR VDPWR sky130_fd_pr__pfet_01v8_hvt ad=0.0882 pd=0.84 as=0.1113 ps=1.37 w=0.42 l=0.15
X286 VGND halfP/dff1.D VGND VGND sky130_fd_pr__nfet_01v8 ad=0.49 pd=3.5 as=0 ps=0 w=1.4 l=2.86
X287 a_10374_39596# halfN/dff6.D halfN/dff3.D VDPWR sky130_fd_pr__pfet_01v8 ad=0.15 pd=1.3 as=0.33 ps=2.66 w=1 l=0.15
X288 VDPWR clk a_24639_42711# VDPWR sky130_fd_pr__pfet_01v8_hvt ad=0.0864 pd=0.91 as=0.1664 ps=1.8 w=0.64 l=0.15
X289 VGND clk a_24639_41623# VGND sky130_fd_pr__nfet_01v8 ad=0.0567 pd=0.69 as=0.1092 ps=1.36 w=0.42 l=0.15
X290 a_3811_40509# clk VGND VGND sky130_fd_pr__nfet_01v8 ad=0.1092 pd=1.36 as=0.0567 ps=0.69 w=0.42 l=0.15
X291 a_13047_41775# a_13143_41597# VDPWR VDPWR sky130_fd_pr__pfet_01v8_hvt ad=0.27 pd=2.54 as=0.135 ps=1.27 w=1 l=0.15
X292 a_26369_41873# halfP/xq3.A VDPWR VDPWR sky130_fd_pr__pfet_01v8_hvt ad=0.135 pd=1.27 as=0.135 ps=1.27 w=1 l=0.15
X293 VGND a_16071_42167# a_16239_42141# VGND sky130_fd_pr__nfet_01v8 ad=0.08775 pd=0.92 as=0.169 ps=1.82 w=0.65 l=0.15
X294 a_4365_43633# a_3811_43473# a_4018_43532# VGND sky130_fd_pr__special_nfet_01v8 ad=0.0813 pd=0.83 as=0.0621 ps=0.705 w=0.36 l=0.15
X295 a_26369_40535# halfP/obuf3.A VGND VGND sky130_fd_pr__nfet_01v8 ad=0.08775 pd=0.92 as=0.08775 ps=0.92 w=0.65 l=0.15
X296 VGND halfN/dff1.D a_11865_41623# VGND sky130_fd_pr__nfet_01v8 ad=0.1092 pd=1.36 as=0.0813 ps=0.83 w=0.42 l=0.15
X297 a_12403_43487# a_12499_43487# VGND VGND sky130_fd_pr__nfet_01v8 ad=0.169 pd=1.82 as=0.08775 ps=0.92 w=0.65 l=0.15
X298 a_25246_43229# a_25078_43255# VGND VGND sky130_fd_pr__nfet_01v8 ad=0.0989 pd=0.995 as=0.12095 ps=1.085 w=0.64 l=0.15
X299 VGND a_12967_42685# a_12974_42985# VGND sky130_fd_pr__nfet_01v8 ad=0.0567 pd=0.69 as=0.1092 ps=1.36 w=0.42 l=0.15
X300 a_16071_42167# a_15207_42173# a_15814_42141# VDPWR sky130_fd_pr__pfet_01v8_hvt ad=0.0567 pd=0.69 as=0.1095 ps=1.075 w=0.42 l=0.15
X301 uio_out[5] a_10411_41597# VGND VGND sky130_fd_pr__nfet_01v8 ad=0.08775 pd=0.92 as=0.169 ps=1.82 w=0.65 l=0.15
X302 VGND halfN/dff5.D VGND VGND sky130_fd_pr__nfet_01v8 ad=0.49 pd=3.5 as=0 ps=0 w=1.4 l=2.86
X303 VGND a_10411_41597# uio_out[5] VGND sky130_fd_pr__nfet_01v8 ad=0.08775 pd=0.92 as=0.08775 ps=0.92 w=0.65 l=0.15
X304 a_4194_40901# a_3947_40535# VDPWR VDPWR sky130_fd_pr__pfet_01v8_hvt ad=0.07665 pd=0.785 as=0.17887 ps=1.26 w=0.42 l=0.15
X305 halfP/dff5.D halfP/dff3.D a_19486_39596# VDPWR sky130_fd_pr__pfet_01v8 ad=0.33 pd=2.66 as=0.15 ps=1.3 w=1 l=0.15
X306 a_13166_43255# a_12919_43633# VDPWR VDPWR sky130_fd_pr__pfet_01v8_hvt ad=0.07665 pd=0.785 as=0.17887 ps=1.26 w=0.42 l=0.15
X307 a_3947_43633# a_3811_43473# a_3527_43487# VDPWR sky130_fd_pr__pfet_01v8_hvt ad=0.1095 pd=1.075 as=0.0567 ps=0.69 w=0.42 l=0.15
X308 a_18647_43255# a_17949_43261# a_18390_43229# VGND sky130_fd_pr__special_nfet_01v8 ad=0.0684 pd=0.74 as=0.0989 ps=0.995 w=0.36 l=0.15
X309 halfP/xq0.B a_25671_43229# VGND VGND sky130_fd_pr__nfet_01v8 ad=0.169 pd=1.82 as=0.08775 ps=0.92 w=0.65 l=0.15
X310 halfP/xq0.B a_25671_43229# VDPWR VDPWR sky130_fd_pr__pfet_01v8_hvt ad=0.26 pd=2.52 as=0.135 ps=1.27 w=1 l=0.15
X311 a_17930_42141# a_17762_42167# VGND VGND sky130_fd_pr__nfet_01v8 ad=0.0989 pd=0.995 as=0.12095 ps=1.085 w=0.64 l=0.15
X312 VDPWR halfP/xq0.B a_26369_43255# VDPWR sky130_fd_pr__pfet_01v8_hvt ad=0.26 pd=2.52 as=0.135 ps=1.27 w=1 l=0.15
X313 VDPWR uio_oe[6] sky130_fd_pr__res_generic_po w=0.48 l=0.5
X314 VDPWR a_12587_42863# halfN/obuf6.A VDPWR sky130_fd_pr__pfet_01v8_hvt ad=0.135 pd=1.27 as=0.26 ps=2.52 w=1 l=0.15
X315 VDPWR a_10747_42399# halfN/obuf3.A VDPWR sky130_fd_pr__pfet_01v8_hvt ad=0.135 pd=1.27 as=0.26 ps=2.52 w=1 l=0.15
X316 VGND a_3431_43487# halfN/xq0.B VGND sky130_fd_pr__nfet_01v8 ad=0.08775 pd=0.92 as=0.169 ps=1.82 w=0.65 l=0.15
X317 a_3431_43487# a_3527_43487# VDPWR VDPWR sky130_fd_pr__pfet_01v8_hvt ad=0.27 pd=2.54 as=0.135 ps=1.27 w=1 l=0.15
X318 a_25587_43255# a_24805_43261# a_25503_43255# VDPWR sky130_fd_pr__pfet_01v8_hvt ad=0.0882 pd=0.84 as=0.0567 ps=0.69 w=0.42 l=0.15
X319 VDPWR a_4018_42444# a_3947_42545# VDPWR sky130_fd_pr__pfet_01v8_hvt ad=0.17887 pd=1.26 as=0.1095 ps=1.075 w=0.75 l=0.15
X320 a_4365_42545# a_3818_42289# a_4018_42444# VDPWR sky130_fd_pr__pfet_01v8_hvt ad=0.05775 pd=0.695 as=0.06825 ps=0.745 w=0.42 l=0.15
X321 VGND a_12343_42141# uio_out[2] VGND sky130_fd_pr__nfet_01v8 ad=0.08775 pd=0.92 as=0.08775 ps=0.92 w=0.65 l=0.15
X322 a_13797_42545# a_13243_42385# a_13450_42444# VGND sky130_fd_pr__special_nfet_01v8 ad=0.0813 pd=0.83 as=0.0621 ps=0.705 w=0.36 l=0.15
X323 halfP/obuf3.A a_18355_42141# VDPWR VDPWR sky130_fd_pr__pfet_01v8_hvt ad=0.26 pd=2.52 as=0.135 ps=1.27 w=1 l=0.15
X324 halfP/dff6.D halfP/dff2.D a_18526_39236# VGND sky130_fd_pr__nfet_01v8 ad=0.165 pd=1.66 as=0.075 ps=0.8 w=0.5 l=0.15
X325 a_4018_40509# a_3811_40509# a_4194_40901# VDPWR sky130_fd_pr__pfet_01v8_hvt ad=0.06825 pd=0.745 as=0.07665 ps=0.785 w=0.42 l=0.15
X326 a_12990_43532# a_12783_43473# a_13166_43255# VDPWR sky130_fd_pr__pfet_01v8_hvt ad=0.06825 pd=0.745 as=0.07665 ps=0.785 w=0.42 l=0.15
X327 VGND halfP/dff2.D VGND VGND sky130_fd_pr__nfet_01v8 ad=0.49 pd=3.5 as=0 ps=0 w=1.4 l=2.86
X328 VGND a_25503_39991# a_25671_39965# VGND sky130_fd_pr__nfet_01v8 ad=0.08775 pd=0.92 as=0.169 ps=1.82 w=0.65 l=0.15
X329 a_10854_39596# halfN/dff2.D halfN/dff6.D VDPWR sky130_fd_pr__pfet_01v8 ad=0.15 pd=1.3 as=0.33 ps=2.66 w=1 l=0.15
X330 VDPWR a_25503_43077# a_25671_42979# VDPWR sky130_fd_pr__pfet_01v8_hvt ad=0.135 pd=1.27 as=0.27 ps=2.54 w=1 l=0.15
X331 a_12343_42141# halfN/xq3.A VGND VGND sky130_fd_pr__nfet_01v8 ad=0.169 pd=1.82 as=0.08775 ps=0.92 w=0.65 l=0.15
X332 a_24805_42173# a_24639_42173# VDPWR VDPWR sky130_fd_pr__pfet_01v8_hvt ad=0.1664 pd=1.8 as=0.0864 ps=0.91 w=0.64 l=0.15
X333 a_2829_39991# a_2799_39965# halfN/xq6.X VDPWR sky130_fd_pr__pfet_01v8_hvt ad=0.26 pd=2.52 as=0.3 ps=2.6 w=1 l=0.15
X334 a_3947_42711# a_3818_42985# a_3527_42685# VGND sky130_fd_pr__special_nfet_01v8 ad=0.0989 pd=0.995 as=0.0684 ps=0.74 w=0.36 l=0.15
X335 uio_out[0] a_14183_42685# VDPWR VDPWR sky130_fd_pr__pfet_01v8_hvt ad=0.135 pd=1.27 as=0.135 ps=1.27 w=1 l=0.15
X336 uo_out[2] a_18611_41623# VGND VGND sky130_fd_pr__nfet_01v8 ad=0.08775 pd=0.92 as=0.08775 ps=0.92 w=0.65 l=0.15
X337 a_3769_41079# a_3431_41311# VDPWR VDPWR sky130_fd_pr__pfet_01v8_hvt ad=0.0882 pd=0.84 as=0.1113 ps=1.37 w=0.42 l=0.15
X338 VDPWR a_19300_24748# a_19300_24748# VDPWR sky130_fd_pr__pfet_01v8 ad=1.32 pd=8.66 as=0.74 ps=4.37 w=4 l=2
X339 VDPWR a_9954_39570# a_9894_39596# VDPWR sky130_fd_pr__pfet_01v8 ad=0.33 pd=2.66 as=0.15 ps=1.3 w=1 l=1
X340 a_2829_42961# halfN/xq1.B VDPWR VDPWR sky130_fd_pr__pfet_01v8_hvt ad=0.135 pd=1.27 as=0.26 ps=2.52 w=1 l=0.15
X341 VDPWR a_14839_42711# uo_out[7] VDPWR sky130_fd_pr__pfet_01v8_hvt ad=0.26 pd=2.52 as=0.135 ps=1.27 w=1 l=0.15
X342 halfN/RDA.R1_9 halfN/RDA.R2_8 VGND sky130_fd_pr__res_xhigh_po_0p35 l=30.3
X343 VGND a_18611_41623# uo_out[2] VGND sky130_fd_pr__nfet_01v8 ad=0.169 pd=1.82 as=0.08775 ps=0.92 w=0.65 l=0.15
X344 VDPWR a_3431_42863# halfN/xq1.B VDPWR sky130_fd_pr__pfet_01v8_hvt ad=0.135 pd=1.27 as=0.26 ps=2.52 w=1 l=0.15
X345 a_25629_42545# a_24639_42173# a_25503_42167# VGND sky130_fd_pr__special_nfet_01v8 ad=0.066 pd=0.745 as=0.0684 ps=0.74 w=0.36 l=0.15
X346 a_17493_41623# halfP/dff1.D VGND VGND sky130_fd_pr__nfet_01v8 ad=0.0813 pd=0.83 as=0.1092 ps=1.36 w=0.42 l=0.15
X347 halfN/RDA.R1_9 halfN/RDA.R2_10 VGND sky130_fd_pr__res_xhigh_po_0p35 l=30.3
X348 halfN/RDA.R1_31 halfN/xq5.X VGND sky130_fd_pr__res_xhigh_po_0p35 l=30.3
X349 VGND halfP/obuf3.A a_18795_42167# VGND sky130_fd_pr__nfet_01v8 ad=0.08775 pd=0.92 as=0.169 ps=1.82 w=0.65 l=0.15
X350 RBT.R1_4 RBT.R2_5 VGND sky130_fd_pr__res_xhigh_po_0p35 l=4.38
X351 a_12499_43487# a_12783_43473# a_12718_43621# VGND sky130_fd_pr__special_nfet_01v8 ad=0.0684 pd=0.74 as=0.066 ps=0.745 w=0.36 l=0.15
X352 VGND a_25671_42141# a_25629_42545# VGND sky130_fd_pr__nfet_01v8 ad=0.1092 pd=1.36 as=0.066 ps=0.745 w=0.42 l=0.15
X353 a_3017_41623# halfN/xq3.B halfN/xq3.X VGND sky130_fd_pr__nfet_01v8 ad=0.08775 pd=0.92 as=0.25025 ps=1.42 w=0.65 l=0.15
X354 VGND a_12863_42399# halfN/xq3.A VGND sky130_fd_pr__nfet_01v8 ad=0.08775 pd=0.92 as=0.169 ps=1.82 w=0.65 l=0.15
X355 VGND a_13450_42444# a_13379_42545# VGND sky130_fd_pr__nfet_01v8 ad=0.12095 pd=1.085 as=0.0989 ps=0.995 w=0.64 l=0.15
X356 VDPWR a_11518_41597# a_11447_41623# VDPWR sky130_fd_pr__pfet_01v8_hvt ad=0.17887 pd=1.26 as=0.1095 ps=1.075 w=0.75 l=0.15
X357 a_15630_41735# a_15462_41989# VDPWR VDPWR sky130_fd_pr__pfet_01v8_hvt ad=0.1095 pd=1.075 as=0.17887 ps=1.26 w=0.75 l=0.15
X358 a_17305_41623# a_17139_41623# VDPWR VDPWR sky130_fd_pr__pfet_01v8_hvt ad=0.1664 pd=1.8 as=0.0864 ps=0.91 w=0.64 l=0.15
X359 VGND a_15887_41989# a_16055_41891# VGND sky130_fd_pr__nfet_01v8 ad=0.08775 pd=0.92 as=0.169 ps=1.82 w=0.65 l=0.15
X360 a_25204_41623# a_24805_41623# a_25078_41989# VGND sky130_fd_pr__special_nfet_01v8 ad=0.0696 pd=0.765 as=0.0621 ps=0.705 w=0.36 l=0.15
X361 VGND a_3811_42385# a_3818_42289# VGND sky130_fd_pr__nfet_01v8 ad=0.0567 pd=0.69 as=0.1092 ps=1.36 w=0.42 l=0.15
X362 VDPWR a_16531_43255# a_16699_43229# VDPWR sky130_fd_pr__pfet_01v8_hvt ad=0.135 pd=1.27 as=0.27 ps=2.54 w=1 l=0.15
X363 VDPWR a_18815_43229# a_18731_43255# VDPWR sky130_fd_pr__pfet_01v8_hvt ad=0.1113 pd=1.37 as=0.0882 ps=0.84 w=0.42 l=0.15
X364 VDPWR a_16515_42979# a_16431_43077# VDPWR sky130_fd_pr__pfet_01v8_hvt ad=0.1113 pd=1.37 as=0.0882 ps=0.84 w=0.42 l=0.15
X365 halfP/xq4.X halfP/xq4.B a_26369_41399# VGND sky130_fd_pr__nfet_01v8 ad=0.25025 pd=1.42 as=0.08775 ps=0.92 w=0.65 l=0.15
X366 a_13243_42385# clk VDPWR VDPWR sky130_fd_pr__pfet_01v8_hvt ad=0.1664 pd=1.8 as=0.0864 ps=0.91 w=0.64 l=0.15
X367 a_2799_43229# halfN/xq0.B a_3185_43255# VDPWR sky130_fd_pr__pfet_01v8_hvt ad=0.26 pd=2.52 as=0.135 ps=1.27 w=1 l=0.15
X368 VGND clk a_17783_43261# VGND sky130_fd_pr__nfet_01v8 ad=0.0567 pd=0.69 as=0.1092 ps=1.36 w=0.42 l=0.15
X369 VDPWR a_18390_43229# a_18317_43255# VDPWR sky130_fd_pr__pfet_01v8_hvt ad=0.17887 pd=1.26 as=0.07665 ps=0.785 w=0.42 l=0.15
X370 uio_out[6] a_10227_42141# VGND VGND sky130_fd_pr__nfet_01v8 ad=0.08775 pd=0.92 as=0.08775 ps=0.92 w=0.65 l=0.15
X371 VGND tie_oe5.LO sky130_fd_pr__res_generic_po w=0.48 l=0.5
X372 VDPWR a_16090_42823# a_16017_43077# VDPWR sky130_fd_pr__pfet_01v8_hvt ad=0.17887 pd=1.26 as=0.07665 ps=0.785 w=0.42 l=0.15
X373 VGND a_26119_40785# halfP/xq5.X VGND sky130_fd_pr__nfet_01v8 ad=0.208 pd=1.94 as=0.25025 ps=1.42 w=0.65 l=0.15
X374 RB.R2_1 RB.R2_1 VGND VGND sky130_fd_pr__nfet_01v8 ad=0.37 pd=2.37 as=0.37 ps=2.37 w=2 l=2
X375 halfN/RDA.R1_27 halfN/RDA.R2_26 VGND sky130_fd_pr__res_xhigh_po_0p35 l=30.3
X376 halfP/dff6.D halfP/dff2.D a_18526_39596# VDPWR sky130_fd_pr__pfet_01v8 ad=0.33 pd=2.66 as=0.15 ps=1.3 w=1 l=0.15
X377 a_12783_43473# clk VGND VGND sky130_fd_pr__nfet_01v8 ad=0.1092 pd=1.36 as=0.0567 ps=0.69 w=0.42 l=0.15
X378 uio_out[5] a_10411_41597# VGND VGND sky130_fd_pr__nfet_01v8 ad=0.08775 pd=0.92 as=0.08775 ps=0.92 w=0.65 l=0.15
X379 a_13981_41623# a_13434_41897# a_13634_41597# VDPWR sky130_fd_pr__pfet_01v8_hvt ad=0.05775 pd=0.695 as=0.06825 ps=0.745 w=0.42 l=0.15
X380 halfP/CM1.C2 halfP/RIN.R2_1 a_17026_24748# VGND sky130_fd_pr__nfet_01v8 ad=2.22 pd=12.37 as=2.22 ps=12.37 w=12 l=3
X381 halfN/RDA.R1_5 halfN/RIN.R2_1 VGND sky130_fd_pr__res_xhigh_po_0p35 l=30.3
X382 a_16106_43255# a_15833_43261# a_16021_43255# VDPWR sky130_fd_pr__pfet_01v8_hvt ad=0.06825 pd=0.745 as=0.05775 ps=0.695 w=0.42 l=0.15
X383 a_3185_42961# halfN/xq1.A VDPWR VDPWR sky130_fd_pr__pfet_01v8_hvt ad=0.135 pd=1.27 as=0.135 ps=1.27 w=1 l=0.15
X384 halfN/RDA.R1_13 halfN/RDA.R2_14 VGND sky130_fd_pr__res_xhigh_po_0p35 l=30.3
X385 a_17578_41989# a_17305_41623# a_17493_41623# VDPWR sky130_fd_pr__pfet_01v8_hvt ad=0.06825 pd=0.745 as=0.05775 ps=0.695 w=0.42 l=0.15
X386 a_24993_41079# halfP/obuf6.A VDPWR VDPWR sky130_fd_pr__pfet_01v8_hvt ad=0.05775 pd=0.695 as=0.1092 ps=1.36 w=0.42 l=0.15
X387 RT.R1_4 RT.R2_3 VGND sky130_fd_pr__res_xhigh_po_0p35 l=4.38
X388 halfN/RDA.R1_27 halfN/RDA.R2_28 VGND sky130_fd_pr__res_xhigh_po_0p35 l=30.3
X389 VDPWR halfN/obuf5.A a_4365_40369# VDPWR sky130_fd_pr__pfet_01v8_hvt ad=0.1092 pd=1.36 as=0.05775 ps=0.695 w=0.42 l=0.15
X390 a_26369_43255# halfP/xq0.A VDPWR VDPWR sky130_fd_pr__pfet_01v8_hvt ad=0.135 pd=1.27 as=0.135 ps=1.27 w=1 l=0.15
X391 VGND a_18795_42167# uo_out[1] VGND sky130_fd_pr__nfet_01v8 ad=0.08775 pd=0.92 as=0.08775 ps=0.92 w=0.65 l=0.15
X392 a_2799_41808# halfN/xq3.A VGND VGND sky130_fd_pr__nfet_01v8 ad=0.08775 pd=0.92 as=0.08775 ps=0.92 w=0.65 l=0.15
X393 halfP/RDA.R1_15 halfP/RDA.R2_16 VGND sky130_fd_pr__res_xhigh_po_0p35 l=30.3
X394 halfP/RDA.R1_1 halfP/RDA.R2_2 VGND sky130_fd_pr__res_xhigh_po_0p35 l=30.3
X395 VGND halfN/dff2.D VGND VGND sky130_fd_pr__nfet_01v8 ad=0.49 pd=3.5 as=0 ps=0 w=1.4 l=2.86
X396 a_18313_42545# a_17323_42173# a_18187_42167# VGND sky130_fd_pr__special_nfet_01v8 ad=0.066 pd=0.745 as=0.0684 ps=0.74 w=0.36 l=0.15
X397 VGND a_25671_41891# a_25629_41623# VGND sky130_fd_pr__nfet_01v8 ad=0.1092 pd=1.36 as=0.066 ps=0.745 w=0.42 l=0.15
X398 uio_out[7] a_9767_43229# VGND VGND sky130_fd_pr__nfet_01v8 ad=0.08775 pd=0.92 as=0.08775 ps=0.92 w=0.65 l=0.15
X399 halfP/RDA.R1_15 halfP/RDA.R2_14 VGND sky130_fd_pr__res_xhigh_po_0p35 l=30.3
X400 VDPWR a_19255_43255# uo_out[0] VDPWR sky130_fd_pr__pfet_01v8_hvt ad=0.26 pd=2.52 as=0.135 ps=1.27 w=1 l=0.15
X401 VDPWR a_3811_42685# a_3818_42985# VDPWR sky130_fd_pr__pfet_01v8_hvt ad=0.0864 pd=0.91 as=0.1664 ps=1.8 w=0.64 l=0.15
X402 a_11510_42167# a_11263_42545# VDPWR VDPWR sky130_fd_pr__pfet_01v8_hvt ad=0.07665 pd=0.785 as=0.17887 ps=1.26 w=0.42 l=0.15
X403 VGND a_3811_41597# a_3818_41897# VGND sky130_fd_pr__nfet_01v8 ad=0.0567 pd=0.69 as=0.1092 ps=1.36 w=0.42 l=0.15
X404 VDPWR a_14183_42685# uio_out[0] VDPWR sky130_fd_pr__pfet_01v8_hvt ad=0.135 pd=1.27 as=0.135 ps=1.27 w=1 l=0.15
X405 VDPWR halfP/xq1.A a_26201_42961# VDPWR sky130_fd_pr__pfet_01v8_hvt ad=0.135 pd=1.27 as=0.135 ps=1.27 w=1 l=0.15
X406 a_3947_42545# a_3818_42289# a_3527_42399# VGND sky130_fd_pr__special_nfet_01v8 ad=0.0989 pd=0.995 as=0.0684 ps=0.74 w=0.36 l=0.15
X407 VGND halfN/xq4.B a_2799_41053# VGND sky130_fd_pr__nfet_01v8 ad=0.169 pd=1.82 as=0.08775 ps=0.92 w=0.65 l=0.15
X408 halfN/xq4.X a_2799_41053# VGND VGND sky130_fd_pr__nfet_01v8 ad=0.25025 pd=1.42 as=0.208 ps=1.94 w=0.65 l=0.15
X409 VGND halfP/xq3.A a_26119_41873# VGND sky130_fd_pr__nfet_01v8 ad=0.08775 pd=0.92 as=0.08775 ps=0.92 w=0.65 l=0.15
X410 VDPWR halfN/obuf6.A a_2829_41079# VDPWR sky130_fd_pr__pfet_01v8_hvt ad=0.135 pd=1.27 as=0.135 ps=1.27 w=1 l=0.15
X411 uo_out[7] a_14839_42711# VGND VGND sky130_fd_pr__nfet_01v8 ad=0.08775 pd=0.92 as=0.08775 ps=0.92 w=0.65 l=0.15
X412 a_2829_41873# a_2799_41808# halfN/xq3.X VDPWR sky130_fd_pr__pfet_01v8_hvt ad=0.26 pd=2.52 as=0.3 ps=2.6 w=1 l=0.15
X413 a_11334_42444# a_11127_42385# a_11510_42167# VDPWR sky130_fd_pr__pfet_01v8_hvt ad=0.06825 pd=0.745 as=0.07665 ps=0.785 w=0.42 l=0.15
X414 halfN/RIN.R1_0 halfN/RIN.R2_1 VGND sky130_fd_pr__res_xhigh_po_0p35 l=4.3
X415 halfN/RDA.R1_23 halfN/RIN.R2_1 VGND sky130_fd_pr__res_xhigh_po_0p35 l=30.3
X416 a_11263_42545# a_11127_42385# a_10843_42399# VDPWR sky130_fd_pr__pfet_01v8_hvt ad=0.1095 pd=1.075 as=0.0567 ps=0.69 w=0.42 l=0.15
X417 a_13783_41623# a_13563_41623# VGND VGND sky130_fd_pr__nfet_01v8 ad=0.0696 pd=0.765 as=0.12095 ps=1.085 w=0.42 l=0.15
X418 RT.R1_6 RBT.R2_0 VGND sky130_fd_pr__res_xhigh_po_0p35 l=4.38
X419 a_4365_40535# a_3811_40509# a_4018_40509# VGND sky130_fd_pr__special_nfet_01v8 ad=0.0813 pd=0.83 as=0.0621 ps=0.705 w=0.36 l=0.15
X420 a_13174_42685# a_12974_42985# a_13323_42711# VGND sky130_fd_pr__special_nfet_01v8 ad=0.0621 pd=0.705 as=0.0696 ps=0.765 w=0.36 l=0.15
X421 a_25204_41457# a_24805_41085# a_25078_41079# VGND sky130_fd_pr__special_nfet_01v8 ad=0.0696 pd=0.765 as=0.0621 ps=0.705 w=0.36 l=0.15
X422 halfP/RDA.R1_27 halfP/RDA.R2_28 VGND sky130_fd_pr__res_xhigh_po_0p35 l=30.3
X423 VGND a_17139_43255# uo_out[3] VGND sky130_fd_pr__nfet_01v8 ad=0.169 pd=1.82 as=0.08775 ps=0.92 w=0.65 l=0.15
X424 a_24993_43255# halfP/xq0.A VGND VGND sky130_fd_pr__nfet_01v8 ad=0.0813 pd=0.83 as=0.1092 ps=1.36 w=0.42 l=0.15
X425 a_11027_41597# a_11311_41597# a_11246_41623# VGND sky130_fd_pr__special_nfet_01v8 ad=0.0684 pd=0.74 as=0.066 ps=0.745 w=0.36 l=0.15
X426 a_26369_41399# halfP/obuf6.A VGND VGND sky130_fd_pr__nfet_01v8 ad=0.08775 pd=0.92 as=0.08775 ps=0.92 w=0.65 l=0.15
X427 halfP/RDA.R1_5 halfP/RDA.R2_4 VGND sky130_fd_pr__res_xhigh_po_0p35 l=30.3
X428 a_16606_39236# a_15786_39096# VGND VGND sky130_fd_pr__nfet_01v8 ad=0.075 pd=0.8 as=0.165 ps=1.66 w=0.5 l=1
X429 uio_out[4] a_11883_43229# VDPWR VDPWR sky130_fd_pr__pfet_01v8_hvt ad=0.135 pd=1.27 as=0.26 ps=2.52 w=1 l=0.15
X430 a_25078_43077# a_24805_42711# a_24993_42711# VDPWR sky130_fd_pr__pfet_01v8_hvt ad=0.06825 pd=0.745 as=0.05775 ps=0.695 w=0.42 l=0.15
X431 VDPWR a_13243_42385# a_13250_42289# VDPWR sky130_fd_pr__pfet_01v8_hvt ad=0.0864 pd=0.91 as=0.1664 ps=1.8 w=0.64 l=0.15
X432 VGND halfN/obuf6.A a_4365_41457# VGND sky130_fd_pr__nfet_01v8 ad=0.1092 pd=1.36 as=0.0813 ps=0.83 w=0.42 l=0.15
X433 halfP/RDA.R1_27 halfP/RDA.R2_26 VGND sky130_fd_pr__res_xhigh_po_0p35 l=30.3
X434 VDPWR a_25671_39965# a_25587_39991# VDPWR sky130_fd_pr__pfet_01v8_hvt ad=0.1113 pd=1.37 as=0.0882 ps=0.84 w=0.42 l=0.15
X435 a_26201_41079# halfP/xq4.B a_26119_41079# VDPWR sky130_fd_pr__pfet_01v8_hvt ad=0.135 pd=1.27 as=0.26 ps=2.52 w=1 l=0.15
X436 halfP/RIN.R2_1 irst.Y halfP/CM1.C2 VGND sky130_fd_pr__nfet_01v8 ad=0.1386 pd=1.5 as=0.1386 ps=1.5 w=0.42 l=0.15
X437 VGND a_9954_39096# a_10374_39236# VGND sky130_fd_pr__nfet_01v8 ad=0.165 pd=1.66 as=0.075 ps=0.8 w=0.5 l=1
X438 a_17677_42167# halfP/dff3.D VGND VGND sky130_fd_pr__nfet_01v8 ad=0.0813 pd=0.83 as=0.1092 ps=1.36 w=0.42 l=0.15
X439 halfP/xq4.X a_26119_41079# a_26369_41079# VDPWR sky130_fd_pr__pfet_01v8_hvt ad=0.3 pd=2.6 as=0.26 ps=2.52 w=1 l=0.15
X440 VDPWR clk a_24639_43261# VDPWR sky130_fd_pr__pfet_01v8_hvt ad=0.0864 pd=0.91 as=0.1664 ps=1.8 w=0.64 l=0.15
X441 a_3811_42385# clk VDPWR VDPWR sky130_fd_pr__pfet_01v8_hvt ad=0.1664 pd=1.8 as=0.0864 ps=0.91 w=0.64 l=0.15
X442 VDPWR a_16495_41623# uo_out[6] VDPWR sky130_fd_pr__pfet_01v8_hvt ad=0.135 pd=1.27 as=0.135 ps=1.27 w=1 l=0.15
X443 a_25078_43077# a_24639_42711# a_24993_42711# VGND sky130_fd_pr__special_nfet_01v8 ad=0.0621 pd=0.705 as=0.0813 ps=0.83 w=0.36 l=0.15
X444 a_17949_43261# a_17783_43261# VDPWR VDPWR sky130_fd_pr__pfet_01v8_hvt ad=0.1664 pd=1.8 as=0.0864 ps=0.91 w=0.64 l=0.15
X445 VDPWR clk a_15483_42711# VDPWR sky130_fd_pr__pfet_01v8_hvt ad=0.0864 pd=0.91 as=0.1664 ps=1.8 w=0.64 l=0.15
X446 VDPWR clk a_17323_42173# VDPWR sky130_fd_pr__pfet_01v8_hvt ad=0.0864 pd=0.91 as=0.1664 ps=1.8 w=0.64 l=0.15
X447 a_3431_42863# a_3527_42685# VGND VGND sky130_fd_pr__nfet_01v8 ad=0.169 pd=1.82 as=0.08775 ps=0.92 w=0.65 l=0.15
X448 a_15741_42167# a_15207_42173# a_15646_42167# VDPWR sky130_fd_pr__pfet_01v8_hvt ad=0.07665 pd=0.785 as=0.06825 ps=0.745 w=0.42 l=0.15
X449 RARR.R1_1 RARR.R2_1 VGND sky130_fd_pr__res_xhigh_po_0p35 l=20
X450 VGND halfN/dff3.D VGND VGND sky130_fd_pr__nfet_01v8 ad=0.49 pd=3.5 as=0 ps=0 w=1.4 l=2.86
X451 VDPWR a_10287_43487# halfN/obuf5.A VDPWR sky130_fd_pr__pfet_01v8_hvt ad=0.135 pd=1.27 as=0.26 ps=2.52 w=1 l=0.15
X452 a_12902_42711# a_12587_42863# VGND VGND sky130_fd_pr__nfet_01v8 ad=0.066 pd=0.745 as=0.1092 ps=1.36 w=0.42 l=0.15
X453 uo_out[7] a_14839_42711# VGND VGND sky130_fd_pr__nfet_01v8 ad=0.08775 pd=0.92 as=0.08775 ps=0.92 w=0.65 l=0.15
X454 VDPWR halfP/obuf5.A a_19255_43255# VDPWR sky130_fd_pr__pfet_01v8_hvt ad=0.135 pd=1.27 as=0.26 ps=2.52 w=1 l=0.15
X455 VGND a_13427_41597# a_13434_41897# VGND sky130_fd_pr__nfet_01v8 ad=0.0567 pd=0.69 as=0.1092 ps=1.36 w=0.42 l=0.15
X456 halfP/xq2.A a_18171_41891# VDPWR VDPWR sky130_fd_pr__pfet_01v8_hvt ad=0.26 pd=2.52 as=0.135 ps=1.27 w=1 l=0.15
X457 a_13337_43633# a_12783_43473# a_12990_43532# VGND sky130_fd_pr__special_nfet_01v8 ad=0.0813 pd=0.83 as=0.0621 ps=0.705 w=0.36 l=0.15
X458 VGND VGND VGND sky130_fd_pr__res_xhigh_po_0p35 l=20
X459 halfP/RDA.R1_31 halfP/xq5.X VGND sky130_fd_pr__res_xhigh_po_0p35 l=30.3
X460 a_11883_43229# halfN/xq1.A VGND VGND sky130_fd_pr__nfet_01v8 ad=0.169 pd=1.82 as=0.08775 ps=0.92 w=0.65 l=0.15
X461 VGND a_18815_43229# a_18773_43633# VGND sky130_fd_pr__nfet_01v8 ad=0.1092 pd=1.36 as=0.066 ps=0.745 w=0.42 l=0.15
X462 uo_out[0] a_19255_43255# VDPWR VDPWR sky130_fd_pr__pfet_01v8_hvt ad=0.135 pd=1.27 as=0.135 ps=1.27 w=1 l=0.15
X463 VDPWR a_15814_42141# a_15741_42167# VDPWR sky130_fd_pr__pfet_01v8_hvt ad=0.17887 pd=1.26 as=0.07665 ps=0.785 w=0.42 l=0.15
X464 a_17578_41989# a_17139_41623# a_17493_41623# VGND sky130_fd_pr__special_nfet_01v8 ad=0.0621 pd=0.705 as=0.0813 ps=0.83 w=0.36 l=0.15
X465 halfP/RDA.R1_29 halfP/RIN.R2_1 VGND sky130_fd_pr__res_xhigh_po_0p35 l=30.3
X466 VDPWR a_16699_43229# a_16615_43255# VDPWR sky130_fd_pr__pfet_01v8_hvt ad=0.1113 pd=1.37 as=0.0882 ps=0.84 w=0.42 l=0.15
X467 a_24993_42711# halfP/xq1.A VGND VGND sky130_fd_pr__nfet_01v8 ad=0.0813 pd=0.83 as=0.1092 ps=1.36 w=0.42 l=0.15
X468 a_25246_42141# a_25078_42167# VDPWR VDPWR sky130_fd_pr__pfet_01v8_hvt ad=0.1095 pd=1.075 as=0.17887 ps=1.26 w=0.75 l=0.15
X469 a_5356_24748# RBT.R2_0 a_6022_24748# VGND sky130_fd_pr__nfet_01v8 ad=2.22 pd=12.37 as=2.22 ps=12.37 w=12 l=3
X470 uio_out[4] a_11883_43229# VDPWR VDPWR sky130_fd_pr__pfet_01v8_hvt ad=0.135 pd=1.27 as=0.135 ps=1.27 w=1 l=0.15
X471 a_3017_42487# halfN/xq2.B halfN/xq2.X VGND sky130_fd_pr__nfet_01v8 ad=0.08775 pd=0.92 as=0.25025 ps=1.42 w=0.65 l=0.15
X472 a_25078_42167# a_24805_42173# a_24993_42167# VDPWR sky130_fd_pr__pfet_01v8_hvt ad=0.06825 pd=0.745 as=0.05775 ps=0.695 w=0.42 l=0.15
X473 VDPWR halfN/dff1.D a_11865_41623# VDPWR sky130_fd_pr__pfet_01v8_hvt ad=0.1092 pd=1.36 as=0.05775 ps=0.695 w=0.42 l=0.15
X474 a_3947_40535# a_3811_40509# a_3527_40509# VDPWR sky130_fd_pr__pfet_01v8_hvt ad=0.1095 pd=1.075 as=0.0567 ps=0.69 w=0.42 l=0.15
X475 VGND a_9954_39096# a_10854_39236# VGND sky130_fd_pr__nfet_01v8 ad=0.165 pd=1.66 as=0.075 ps=0.8 w=0.5 l=1
X476 VGND halfN/obuf3.A a_4365_40535# VGND sky130_fd_pr__nfet_01v8 ad=0.1092 pd=1.36 as=0.0813 ps=0.83 w=0.42 l=0.15
X477 a_12919_43633# a_12783_43473# a_12499_43487# VDPWR sky130_fd_pr__pfet_01v8_hvt ad=0.1095 pd=1.075 as=0.0567 ps=0.69 w=0.42 l=0.15
X478 VGND a_13174_42685# a_13103_42711# VGND sky130_fd_pr__nfet_01v8 ad=0.12095 pd=1.085 as=0.0989 ps=0.995 w=0.64 l=0.15
X479 VGND RB.R2_1 RB.R2_1 VGND sky130_fd_pr__nfet_01v8 ad=0.66 pd=4.66 as=0.37 ps=2.37 w=2 l=2
X480 uio_oe[1] VDPWR sky130_fd_pr__res_generic_po w=0.48 l=0.5
X481 a_16606_39596# a_15306_39570# VDPWR VDPWR sky130_fd_pr__pfet_01v8 ad=0.15 pd=1.3 as=0.33 ps=2.66 w=1 l=1
X482 VDPWR a_9954_39570# a_10374_39596# VDPWR sky130_fd_pr__pfet_01v8 ad=0.33 pd=2.66 as=0.15 ps=1.3 w=1 l=1
X483 a_25587_40901# a_24805_40535# a_25503_40901# VDPWR sky130_fd_pr__pfet_01v8_hvt ad=0.0882 pd=0.84 as=0.0567 ps=0.69 w=0.42 l=0.15
X484 VGND a_12403_43487# halfN/xq1.A VGND sky130_fd_pr__nfet_01v8 ad=0.08775 pd=0.92 as=0.169 ps=1.82 w=0.65 l=0.15
X485 a_10843_42399# a_11134_42289# a_11085_42167# VDPWR sky130_fd_pr__pfet_01v8_hvt ad=0.0567 pd=0.69 as=0.0882 ps=0.84 w=0.42 l=0.15
X486 irst.Y rst_n VDPWR VDPWR sky130_fd_pr__pfet_01v8_hvt ad=0.26 pd=2.52 as=0.26 ps=2.52 w=1 l=0.15
X487 halfP/CM1.C2 halfP/RIN.R2_1 a_17026_24748# VGND sky130_fd_pr__nfet_01v8 ad=2.22 pd=12.37 as=2.22 ps=12.37 w=12 l=3
X488 VGND a_25503_40901# a_25671_40803# VGND sky130_fd_pr__nfet_01v8 ad=0.08775 pd=0.92 as=0.169 ps=1.82 w=0.65 l=0.15
X489 a_12919_43633# a_12790_43377# a_12499_43487# VGND sky130_fd_pr__special_nfet_01v8 ad=0.0989 pd=0.995 as=0.0684 ps=0.74 w=0.36 l=0.15
X490 VDPWR a_16347_43077# a_16515_42979# VDPWR sky130_fd_pr__pfet_01v8_hvt ad=0.135 pd=1.27 as=0.27 ps=2.54 w=1 l=0.15
X491 VGND halfN/dff6.D VGND VGND sky130_fd_pr__nfet_01v8 ad=0.49 pd=3.5 as=0 ps=0 w=1.4 l=2.86
X492 a_4365_40369# a_3811_40209# a_4018_40268# VGND sky130_fd_pr__special_nfet_01v8 ad=0.0813 pd=0.83 as=0.0621 ps=0.705 w=0.36 l=0.15
X493 VGND halfN/xq1.A a_3017_42711# VGND sky130_fd_pr__nfet_01v8 ad=0.08775 pd=0.92 as=0.08775 ps=0.92 w=0.65 l=0.15
X494 VGND a_26119_41079# halfP/xq4.X VGND sky130_fd_pr__nfet_01v8 ad=0.208 pd=1.94 as=0.25025 ps=1.42 w=0.65 l=0.15
X495 halfP/RDA.R1_7 halfP/RDA.R2_8 VGND sky130_fd_pr__res_xhigh_po_0p35 l=30.3
X496 VDPWR a_10667_43473# a_10674_43377# VDPWR sky130_fd_pr__pfet_01v8_hvt ad=0.0864 pd=0.91 as=0.1664 ps=1.8 w=0.64 l=0.15
X497 uo_out[3] a_17139_43255# VDPWR VDPWR sky130_fd_pr__pfet_01v8_hvt ad=0.135 pd=1.27 as=0.135 ps=1.27 w=1 l=0.15
X498 a_12959_42399# a_13243_42385# a_13178_42533# VGND sky130_fd_pr__special_nfet_01v8 ad=0.0684 pd=0.74 as=0.066 ps=0.745 w=0.36 l=0.15
X499 a_24805_42173# a_24639_42173# VGND VGND sky130_fd_pr__nfet_01v8 ad=0.1092 pd=1.36 as=0.0567 ps=0.69 w=0.42 l=0.15
X500 halfP/CM1.C2 a_19300_24748# VDPWR VDPWR sky130_fd_pr__pfet_01v8 ad=0.74 pd=4.37 as=0.74 ps=4.37 w=4 l=2
X501 a_5356_24748# RBT.R2_0 a_6022_24748# VGND sky130_fd_pr__nfet_01v8 ad=3.96 pd=24.66 as=2.22 ps=12.37 w=12 l=3
X502 a_2829_43255# a_2799_43229# halfN/xq0.X VDPWR sky130_fd_pr__pfet_01v8_hvt ad=0.26 pd=2.52 as=0.3 ps=2.6 w=1 l=0.15
X503 a_3746_42533# a_3431_42399# VGND VGND sky130_fd_pr__nfet_01v8 ad=0.066 pd=0.745 as=0.1092 ps=1.36 w=0.42 l=0.15
X504 a_3527_41597# a_3818_41897# a_3769_41989# VDPWR sky130_fd_pr__pfet_01v8_hvt ad=0.0567 pd=0.69 as=0.0882 ps=0.84 w=0.42 l=0.15
X505 a_4365_40369# a_3818_40113# a_4018_40268# VDPWR sky130_fd_pr__pfet_01v8_hvt ad=0.05775 pd=0.695 as=0.06825 ps=0.745 w=0.42 l=0.15
X506 a_17493_41623# halfP/dff1.D VDPWR VDPWR sky130_fd_pr__pfet_01v8_hvt ad=0.05775 pd=0.695 as=0.1092 ps=1.36 w=0.42 l=0.15
X507 a_16013_41623# a_15023_41623# a_15887_41989# VGND sky130_fd_pr__special_nfet_01v8 ad=0.066 pd=0.745 as=0.0684 ps=0.74 w=0.36 l=0.15
X508 VDPWR a_4018_40268# a_3947_40369# VDPWR sky130_fd_pr__pfet_01v8_hvt ad=0.17887 pd=1.26 as=0.1095 ps=1.075 w=0.75 l=0.15
X509 a_2799_42141# halfN/xq2.A VGND VGND sky130_fd_pr__nfet_01v8 ad=0.08775 pd=0.92 as=0.08775 ps=0.92 w=0.65 l=0.15
X510 a_25078_42167# a_24639_42173# a_24993_42167# VGND sky130_fd_pr__special_nfet_01v8 ad=0.0621 pd=0.705 as=0.0813 ps=0.83 w=0.36 l=0.15
X511 a_4018_41597# a_3818_41897# a_4167_41623# VGND sky130_fd_pr__special_nfet_01v8 ad=0.0621 pd=0.705 as=0.0696 ps=0.765 w=0.36 l=0.15
X512 a_25503_41989# a_24639_41623# a_25246_41735# VDPWR sky130_fd_pr__pfet_01v8_hvt ad=0.0567 pd=0.69 as=0.1095 ps=1.075 w=0.42 l=0.15
X513 uio_out[0] a_14183_42685# VGND VGND sky130_fd_pr__nfet_01v8 ad=0.08775 pd=0.92 as=0.169 ps=1.82 w=0.65 l=0.15
X514 a_26119_42961# halfP/xq1.B VGND VGND sky130_fd_pr__nfet_01v8 ad=0.08775 pd=0.92 as=0.169 ps=1.82 w=0.65 l=0.15
X515 a_25173_41989# a_24639_41623# a_25078_41989# VDPWR sky130_fd_pr__pfet_01v8_hvt ad=0.07665 pd=0.785 as=0.06825 ps=0.745 w=0.42 l=0.15
X516 uo_out[2] a_18611_41623# VGND VGND sky130_fd_pr__nfet_01v8 ad=0.08775 pd=0.92 as=0.08775 ps=0.92 w=0.65 l=0.15
X517 VGND a_14839_42711# uo_out[7] VGND sky130_fd_pr__nfet_01v8 ad=0.08775 pd=0.92 as=0.08775 ps=0.92 w=0.65 l=0.15
X518 a_17930_42141# a_17762_42167# VDPWR VDPWR sky130_fd_pr__pfet_01v8_hvt ad=0.1095 pd=1.075 as=0.17887 ps=1.26 w=0.75 l=0.15
X519 VDPWR a_4018_40509# a_3947_40535# VDPWR sky130_fd_pr__pfet_01v8_hvt ad=0.17887 pd=1.26 as=0.1095 ps=1.075 w=0.75 l=0.15
X520 VDPWR a_9954_39570# a_10854_39596# VDPWR sky130_fd_pr__pfet_01v8 ad=0.33 pd=2.66 as=0.15 ps=1.3 w=1 l=1
X521 VGND clk a_17139_41623# VGND sky130_fd_pr__nfet_01v8 ad=0.0567 pd=0.69 as=0.1092 ps=1.36 w=0.42 l=0.15
X522 a_10287_43487# a_10383_43487# VGND VGND sky130_fd_pr__nfet_01v8 ad=0.169 pd=1.82 as=0.08775 ps=0.92 w=0.65 l=0.15
X523 uio_oe[5] VDPWR sky130_fd_pr__res_generic_po w=0.48 l=0.5
X524 a_13243_42385# clk VGND VGND sky130_fd_pr__nfet_01v8 ad=0.1092 pd=1.36 as=0.0567 ps=0.69 w=0.42 l=0.15
X525 halfP/RIN.R1_0 ua[0] VGND sky130_fd_pr__res_xhigh_po_0p35 l=4.3
X526 a_4167_43621# a_3947_43633# VGND VGND sky130_fd_pr__nfet_01v8 ad=0.0696 pd=0.765 as=0.12095 ps=1.085 w=0.42 l=0.15
X527 a_11050_43255# a_10803_43633# VDPWR VDPWR sky130_fd_pr__pfet_01v8_hvt ad=0.07665 pd=0.785 as=0.17887 ps=1.26 w=0.42 l=0.15
X528 VGND halfP/xq2.A a_26119_42167# VGND sky130_fd_pr__nfet_01v8 ad=0.08775 pd=0.92 as=0.08775 ps=0.92 w=0.65 l=0.15
X529 VDPWR a_25246_41735# a_25173_41989# VDPWR sky130_fd_pr__pfet_01v8_hvt ad=0.17887 pd=1.26 as=0.07665 ps=0.785 w=0.42 l=0.15
X530 a_16531_43255# a_15833_43261# a_16274_43229# VGND sky130_fd_pr__special_nfet_01v8 ad=0.0684 pd=0.74 as=0.0989 ps=0.995 w=0.36 l=0.15
X531 halfP/RDA.R1_11 halfP/RDA.R2_10 VGND sky130_fd_pr__res_xhigh_po_0p35 l=30.3
X532 VGND a_25246_42141# a_25204_42545# VGND sky130_fd_pr__nfet_01v8 ad=0.12095 pd=1.085 as=0.0696 ps=0.765 w=0.42 l=0.15
X533 a_24805_42711# a_24639_42711# VDPWR VDPWR sky130_fd_pr__pfet_01v8_hvt ad=0.1664 pd=1.8 as=0.0864 ps=0.91 w=0.64 l=0.15
X534 a_24805_41623# a_24639_41623# VGND VGND sky130_fd_pr__nfet_01v8 ad=0.1092 pd=1.36 as=0.0567 ps=0.69 w=0.42 l=0.15
X535 VGND a_10227_42141# uio_out[6] VGND sky130_fd_pr__nfet_01v8 ad=0.08775 pd=0.92 as=0.08775 ps=0.92 w=0.65 l=0.15
X536 a_11681_42545# a_11127_42385# a_11334_42444# VGND sky130_fd_pr__special_nfet_01v8 ad=0.0813 pd=0.83 as=0.0621 ps=0.705 w=0.36 l=0.15
X537 halfP/xq3.A a_16239_42141# VGND VGND sky130_fd_pr__nfet_01v8 ad=0.169 pd=1.82 as=0.08775 ps=0.92 w=0.65 l=0.15
X538 halfP/xq3.A a_16239_42141# VDPWR VDPWR sky130_fd_pr__pfet_01v8_hvt ad=0.26 pd=2.52 as=0.135 ps=1.27 w=1 l=0.15
X539 VDPWR a_3811_43473# a_3818_43377# VDPWR sky130_fd_pr__pfet_01v8_hvt ad=0.0864 pd=0.91 as=0.1664 ps=1.8 w=0.64 l=0.15
X540 a_10874_43532# a_10667_43473# a_11050_43255# VDPWR sky130_fd_pr__pfet_01v8_hvt ad=0.06825 pd=0.745 as=0.07665 ps=0.785 w=0.42 l=0.15
X541 a_3746_41623# a_3431_41775# VGND VGND sky130_fd_pr__nfet_01v8 ad=0.066 pd=0.745 as=0.1092 ps=1.36 w=0.42 l=0.15
X542 VDPWR a_16055_41891# a_15971_41989# VDPWR sky130_fd_pr__pfet_01v8_hvt ad=0.1113 pd=1.37 as=0.0882 ps=0.84 w=0.42 l=0.15
X543 a_10227_42141# halfN/obuf3.A VGND VGND sky130_fd_pr__nfet_01v8 ad=0.169 pd=1.82 as=0.08775 ps=0.92 w=0.65 l=0.15
X544 VDPWR halfN/xq0.A a_4365_43633# VDPWR sky130_fd_pr__pfet_01v8_hvt ad=0.1092 pd=1.36 as=0.05775 ps=0.695 w=0.42 l=0.15
X545 a_12967_42685# clk VGND VGND sky130_fd_pr__nfet_01v8 ad=0.1092 pd=1.36 as=0.0567 ps=0.69 w=0.42 l=0.15
X546 a_16155_42167# a_15373_42173# a_16071_42167# VDPWR sky130_fd_pr__pfet_01v8_hvt ad=0.0882 pd=0.84 as=0.0567 ps=0.69 w=0.42 l=0.15
X547 uo_out[6] a_16495_41623# VGND VGND sky130_fd_pr__nfet_01v8 ad=0.08775 pd=0.92 as=0.08775 ps=0.92 w=0.65 l=0.15
X548 a_25503_43255# a_24805_43261# a_25246_43229# VGND sky130_fd_pr__special_nfet_01v8 ad=0.0684 pd=0.74 as=0.0989 ps=0.995 w=0.36 l=0.15
X549 a_13599_42533# a_13379_42545# VGND VGND sky130_fd_pr__nfet_01v8 ad=0.0696 pd=0.765 as=0.12095 ps=1.085 w=0.42 l=0.15
X550 halfN/RDA.R1_3 halfN/RDA.R2_2 VGND sky130_fd_pr__res_xhigh_po_0p35 l=30.3
X551 VGND a_16495_41623# uo_out[6] VGND sky130_fd_pr__nfet_01v8 ad=0.169 pd=1.82 as=0.08775 ps=0.92 w=0.65 l=0.15
X552 a_10411_41597# halfN/xq2.A VGND VGND sky130_fd_pr__nfet_01v8 ad=0.169 pd=1.82 as=0.08775 ps=0.92 w=0.65 l=0.15
X553 halfN/RDA.R1_25 halfN/xq4.X VGND sky130_fd_pr__res_xhigh_po_0p35 l=30.3
X554 VGND halfP/xq3.A a_16679_42167# VGND sky130_fd_pr__nfet_01v8 ad=0.08775 pd=0.92 as=0.169 ps=1.82 w=0.65 l=0.15
X555 a_18187_42167# a_17489_42173# a_17930_42141# VGND sky130_fd_pr__special_nfet_01v8 ad=0.0684 pd=0.74 as=0.0989 ps=0.995 w=0.36 l=0.15
X556 VGND a_4018_41597# a_3947_41623# VGND sky130_fd_pr__nfet_01v8 ad=0.12095 pd=1.085 as=0.0989 ps=0.995 w=0.64 l=0.15
X557 a_25246_39965# a_25078_39991# VGND VGND sky130_fd_pr__nfet_01v8 ad=0.0989 pd=0.995 as=0.12095 ps=1.085 w=0.64 l=0.15
X558 a_10747_42399# a_10843_42399# VDPWR VDPWR sky130_fd_pr__pfet_01v8_hvt ad=0.27 pd=2.54 as=0.135 ps=1.27 w=1 l=0.15
X559 uo_out[5] a_16679_42167# VGND VGND sky130_fd_pr__nfet_01v8 ad=0.08775 pd=0.92 as=0.08775 ps=0.92 w=0.65 l=0.15
X560 a_11447_41623# a_11318_41897# a_11027_41597# VGND sky130_fd_pr__special_nfet_01v8 ad=0.0989 pd=0.995 as=0.0684 ps=0.74 w=0.36 l=0.15
X561 halfP/RDA.R1_23 halfP/RDA.R2_22 VGND sky130_fd_pr__res_xhigh_po_0p35 l=30.3
X562 VDPWR a_11311_41597# a_11318_41897# VDPWR sky130_fd_pr__pfet_01v8_hvt ad=0.0864 pd=0.91 as=0.1664 ps=1.8 w=0.64 l=0.15
X563 a_4167_42711# a_3947_42711# VGND VGND sky130_fd_pr__nfet_01v8 ad=0.0696 pd=0.765 as=0.12095 ps=1.085 w=0.42 l=0.15
X564 a_13521_42711# a_12974_42985# a_13174_42685# VDPWR sky130_fd_pr__pfet_01v8_hvt ad=0.05775 pd=0.695 as=0.06825 ps=0.745 w=0.42 l=0.15
X565 a_3431_43487# a_3527_43487# VGND VGND sky130_fd_pr__nfet_01v8 ad=0.169 pd=1.82 as=0.08775 ps=0.92 w=0.65 l=0.15
X566 halfP/xq6.B a_25671_39965# VGND VGND sky130_fd_pr__nfet_01v8 ad=0.169 pd=1.82 as=0.08775 ps=0.92 w=0.65 l=0.15
X567 VDPWR halfN/dff2.D a_13797_42545# VDPWR sky130_fd_pr__pfet_01v8_hvt ad=0.1092 pd=1.36 as=0.05775 ps=0.695 w=0.42 l=0.15
X568 VGND a_10931_41775# halfN/xq2.A VGND sky130_fd_pr__nfet_01v8 ad=0.08775 pd=0.92 as=0.169 ps=1.82 w=0.65 l=0.15
X569 VGND a_25246_41735# a_25204_41623# VGND sky130_fd_pr__nfet_01v8 ad=0.12095 pd=1.085 as=0.0696 ps=0.765 w=0.42 l=0.15
X570 a_13103_42711# a_12967_42685# a_12683_42685# VDPWR sky130_fd_pr__pfet_01v8_hvt ad=0.1095 pd=1.075 as=0.0567 ps=0.69 w=0.42 l=0.15
X571 halfP/xq1.B a_25671_42979# VDPWR VDPWR sky130_fd_pr__pfet_01v8_hvt ad=0.26 pd=2.52 as=0.135 ps=1.27 w=1 l=0.15
X572 uio_out[2] a_12343_42141# VDPWR VDPWR sky130_fd_pr__pfet_01v8_hvt ad=0.135 pd=1.27 as=0.26 ps=2.52 w=1 l=0.15
X573 VDPWR a_14183_42685# uio_out[0] VDPWR sky130_fd_pr__pfet_01v8_hvt ad=0.135 pd=1.27 as=0.135 ps=1.27 w=1 l=0.15
X574 VDPWR halfP/xq1.B a_26369_42961# VDPWR sky130_fd_pr__pfet_01v8_hvt ad=0.26 pd=2.52 as=0.135 ps=1.27 w=1 l=0.15
X575 a_4018_41356# a_3818_41201# a_4167_41445# VGND sky130_fd_pr__special_nfet_01v8 ad=0.0621 pd=0.705 as=0.0696 ps=0.765 w=0.36 l=0.15
X576 a_25246_42823# a_25078_43077# VGND VGND sky130_fd_pr__nfet_01v8 ad=0.0989 pd=0.995 as=0.12095 ps=1.085 w=0.64 l=0.15
X577 VDPWR a_12343_42141# uio_out[2] VDPWR sky130_fd_pr__pfet_01v8_hvt ad=0.135 pd=1.27 as=0.135 ps=1.27 w=1 l=0.15
X578 VGND a_3431_40223# halfN/xq6.B VGND sky130_fd_pr__nfet_01v8 ad=0.08775 pd=0.92 as=0.169 ps=1.82 w=0.65 l=0.15
X579 RB.R1_0 RB.R2_1 VGND sky130_fd_pr__res_xhigh_po_0p35 l=3.65
X580 VGND a_10287_43487# halfN/obuf5.A VGND sky130_fd_pr__nfet_01v8 ad=0.08775 pd=0.92 as=0.169 ps=1.82 w=0.65 l=0.15
X581 a_12718_43621# a_12403_43487# VGND VGND sky130_fd_pr__nfet_01v8 ad=0.066 pd=0.745 as=0.1092 ps=1.36 w=0.42 l=0.15
X582 a_3431_42863# a_3527_42685# VDPWR VDPWR sky130_fd_pr__pfet_01v8_hvt ad=0.27 pd=2.54 as=0.135 ps=1.27 w=1 l=0.15
X583 halfP/xq3.X halfP/xq3.B a_26369_41623# VGND sky130_fd_pr__nfet_01v8 ad=0.25025 pd=1.42 as=0.08775 ps=0.92 w=0.65 l=0.15
X584 halfN/RDA.R1_21 halfN/RDA.R2_20 VGND sky130_fd_pr__res_xhigh_po_0p35 l=30.3
X585 VGND a_13243_42385# a_13250_42289# VGND sky130_fd_pr__nfet_01v8 ad=0.0567 pd=0.69 as=0.1092 ps=1.36 w=0.42 l=0.15
X586 a_4194_41989# a_3947_41623# VDPWR VDPWR sky130_fd_pr__pfet_01v8_hvt ad=0.07665 pd=0.785 as=0.17887 ps=1.26 w=0.42 l=0.15
X587 a_11865_41623# a_11318_41897# a_11518_41597# VDPWR sky130_fd_pr__pfet_01v8_hvt ad=0.05775 pd=0.695 as=0.06825 ps=0.745 w=0.42 l=0.15
X588 halfN/RDA.R1_0 VGND VGND sky130_fd_pr__res_xhigh_po_0p35 l=30.3
X589 a_12863_42399# a_12959_42399# VGND VGND sky130_fd_pr__nfet_01v8 ad=0.169 pd=1.82 as=0.08775 ps=0.92 w=0.65 l=0.15
X590 VDPWR a_25671_43229# a_25587_43255# VDPWR sky130_fd_pr__pfet_01v8_hvt ad=0.1113 pd=1.37 as=0.0882 ps=0.84 w=0.42 l=0.15
X591 a_15462_41989# a_15189_41623# a_15377_41623# VDPWR sky130_fd_pr__pfet_01v8_hvt ad=0.06825 pd=0.745 as=0.05775 ps=0.695 w=0.42 l=0.15
X592 a_17746_41735# a_17578_41989# VGND VGND sky130_fd_pr__nfet_01v8 ad=0.0989 pd=0.995 as=0.12095 ps=1.085 w=0.64 l=0.15
X593 VGND clk a_24639_43261# VGND sky130_fd_pr__nfet_01v8 ad=0.0567 pd=0.69 as=0.1092 ps=1.36 w=0.42 l=0.15
X594 a_3811_42385# clk VGND VGND sky130_fd_pr__nfet_01v8 ad=0.1092 pd=1.36 as=0.0567 ps=0.69 w=0.42 l=0.15
X595 a_13362_41623# a_13047_41775# VGND VGND sky130_fd_pr__nfet_01v8 ad=0.066 pd=0.745 as=0.1092 ps=1.36 w=0.42 l=0.15
X596 uio_out[6] a_10227_42141# VGND VGND sky130_fd_pr__nfet_01v8 ad=0.08775 pd=0.92 as=0.169 ps=1.82 w=0.65 l=0.15
X597 VDPWR a_16071_42167# a_16239_42141# VDPWR sky130_fd_pr__pfet_01v8_hvt ad=0.135 pd=1.27 as=0.27 ps=2.54 w=1 l=0.15
X598 VDPWR a_18355_42141# a_18271_42167# VDPWR sky130_fd_pr__pfet_01v8_hvt ad=0.1113 pd=1.37 as=0.0882 ps=0.84 w=0.42 l=0.15
X599 a_4018_41597# a_3811_41597# a_4194_41989# VDPWR sky130_fd_pr__pfet_01v8_hvt ad=0.06825 pd=0.745 as=0.07665 ps=0.785 w=0.42 l=0.15
X600 a_3527_41311# a_3818_41201# a_3769_41079# VDPWR sky130_fd_pr__pfet_01v8_hvt ad=0.0567 pd=0.69 as=0.0882 ps=0.84 w=0.42 l=0.15
X601 VGND a_25503_41079# a_25671_41053# VGND sky130_fd_pr__nfet_01v8 ad=0.08775 pd=0.92 as=0.169 ps=1.82 w=0.65 l=0.15
X602 VDPWR a_25503_41079# a_25671_41053# VDPWR sky130_fd_pr__pfet_01v8_hvt ad=0.135 pd=1.27 as=0.27 ps=2.54 w=1 l=0.15
X603 a_17949_43261# a_17783_43261# VGND VGND sky130_fd_pr__nfet_01v8 ad=0.1092 pd=1.36 as=0.0567 ps=0.69 w=0.42 l=0.15
X604 a_24993_39991# halfP/obuf5.A VGND VGND sky130_fd_pr__nfet_01v8 ad=0.0813 pd=0.83 as=0.1092 ps=1.36 w=0.42 l=0.15
X605 a_3527_43487# a_3811_43473# a_3746_43621# VGND sky130_fd_pr__special_nfet_01v8 ad=0.0684 pd=0.74 as=0.066 ps=0.745 w=0.36 l=0.15
X606 VGND a_10227_42141# uio_out[6] VGND sky130_fd_pr__nfet_01v8 ad=0.08775 pd=0.92 as=0.08775 ps=0.92 w=0.65 l=0.15
X607 a_13201_42167# a_12863_42399# VDPWR VDPWR sky130_fd_pr__pfet_01v8_hvt ad=0.0882 pd=0.84 as=0.1113 ps=1.37 w=0.42 l=0.15
X608 VGND clk a_17323_42173# VGND sky130_fd_pr__nfet_01v8 ad=0.0567 pd=0.69 as=0.1092 ps=1.36 w=0.42 l=0.15
X609 a_2829_41079# halfN/xq4.B VDPWR VDPWR sky130_fd_pr__pfet_01v8_hvt ad=0.135 pd=1.27 as=0.26 ps=2.52 w=1 l=0.15
X610 a_15306_39570# a_15306_39570# VDPWR VDPWR sky130_fd_pr__pfet_01v8 ad=0.33 pd=2.66 as=0.33 ps=2.66 w=1 l=1
X611 VGND halfN/xq0.A a_3017_43575# VGND sky130_fd_pr__nfet_01v8 ad=0.08775 pd=0.92 as=0.08775 ps=0.92 w=0.65 l=0.15
X612 VDPWR a_12067_42685# uio_out[3] VDPWR sky130_fd_pr__pfet_01v8_hvt ad=0.135 pd=1.27 as=0.135 ps=1.27 w=1 l=0.15
X613 VGND halfP/xq0.A a_16495_41623# VGND sky130_fd_pr__nfet_01v8 ad=0.08775 pd=0.92 as=0.169 ps=1.82 w=0.65 l=0.15
X614 VDPWR a_3431_41311# halfN/xq4.B VDPWR sky130_fd_pr__pfet_01v8_hvt ad=0.135 pd=1.27 as=0.26 ps=2.52 w=1 l=0.15
X615 a_25503_41079# a_24639_41085# a_25246_41053# VDPWR sky130_fd_pr__pfet_01v8_hvt ad=0.0567 pd=0.69 as=0.1095 ps=1.075 w=0.42 l=0.15
X616 a_11023_43621# a_10803_43633# VGND VGND sky130_fd_pr__nfet_01v8 ad=0.0696 pd=0.765 as=0.12095 ps=1.085 w=0.42 l=0.15
X617 VGND a_18171_41891# a_18129_41623# VGND sky130_fd_pr__nfet_01v8 ad=0.1092 pd=1.36 as=0.066 ps=0.745 w=0.42 l=0.15
X618 a_25173_41079# a_24639_41085# a_25078_41079# VDPWR sky130_fd_pr__pfet_01v8_hvt ad=0.07665 pd=0.785 as=0.06825 ps=0.745 w=0.42 l=0.15
X619 uo_out[6] a_16495_41623# VGND VGND sky130_fd_pr__nfet_01v8 ad=0.08775 pd=0.92 as=0.08775 ps=0.92 w=0.65 l=0.15
X620 a_15837_42711# halfP/dff6.D VGND VGND sky130_fd_pr__nfet_01v8 ad=0.0813 pd=0.83 as=0.1092 ps=1.36 w=0.42 l=0.15
X621 uo_out[4] a_16955_42711# VDPWR VDPWR sky130_fd_pr__pfet_01v8_hvt ad=0.135 pd=1.27 as=0.135 ps=1.27 w=1 l=0.15
X622 a_17026_24748# RB.R2_1 VGND VGND sky130_fd_pr__nfet_01v8 ad=0.37 pd=2.37 as=0.66 ps=4.66 w=2 l=2
X623 halfP/RIN.R2_1 halfP/CM1.C2 sky130_fd_pr__cap_mim_m3_1 l=25 w=24
X624 a_18222_43255# a_17783_43261# a_18137_43255# VGND sky130_fd_pr__special_nfet_01v8 ad=0.0621 pd=0.705 as=0.0813 ps=0.83 w=0.36 l=0.15
X625 a_2799_42896# halfN/xq1.B a_3185_42961# VDPWR sky130_fd_pr__pfet_01v8_hvt ad=0.26 pd=2.52 as=0.135 ps=1.27 w=1 l=0.15
X626 RT.R1_0 VDPWR VGND sky130_fd_pr__res_xhigh_po_0p35 l=4.38
X627 VGND RARR.R2_1 VGND sky130_fd_pr__res_xhigh_po_0p35 l=20
X628 halfN/RDA.R1_17 halfN/RIN.R2_1 VGND sky130_fd_pr__res_xhigh_po_0p35 l=30.3
X629 VGND a_16679_42167# uo_out[5] VGND sky130_fd_pr__nfet_01v8 ad=0.08775 pd=0.92 as=0.08775 ps=0.92 w=0.65 l=0.15
X630 RARR.R1_1 halfN/CM1.C2 a_9954_39570# VGND sky130_fd_pr__nfet_01v8 ad=1.32 pd=8.66 as=1.32 ps=8.66 w=4 l=1
X631 halfN/xq3.X a_2799_41808# VGND VGND sky130_fd_pr__nfet_01v8 ad=0.25025 pd=1.42 as=0.208 ps=1.94 w=0.65 l=0.15
X632 VGND halfN/xq3.B a_2799_41808# VGND sky130_fd_pr__nfet_01v8 ad=0.169 pd=1.82 as=0.08775 ps=0.92 w=0.65 l=0.15
X633 VDPWR clk a_15023_41623# VDPWR sky130_fd_pr__pfet_01v8_hvt ad=0.0864 pd=0.91 as=0.1664 ps=1.8 w=0.64 l=0.15
X634 VDPWR a_25246_41053# a_25173_41079# VDPWR sky130_fd_pr__pfet_01v8_hvt ad=0.17887 pd=1.26 as=0.07665 ps=0.785 w=0.42 l=0.15
X635 a_26119_43255# halfP/xq0.B VGND VGND sky130_fd_pr__nfet_01v8 ad=0.08775 pd=0.92 as=0.169 ps=1.82 w=0.65 l=0.15
X636 halfP/RDA.R1_33 halfP/RDA.R2_34 VGND sky130_fd_pr__res_xhigh_po_0p35 l=30.3
X637 a_19486_39236# a_15786_39096# VGND VGND sky130_fd_pr__nfet_01v8 ad=0.075 pd=0.8 as=0.165 ps=1.66 w=0.5 l=1
X638 a_13379_42545# a_13250_42289# a_12959_42399# VGND sky130_fd_pr__special_nfet_01v8 ad=0.0989 pd=0.995 as=0.0684 ps=0.74 w=0.36 l=0.15
X639 VGND a_4018_43532# a_3947_43633# VGND sky130_fd_pr__nfet_01v8 ad=0.12095 pd=1.085 as=0.0989 ps=0.995 w=0.64 l=0.15
X640 a_16021_43255# halfP/dff4.D VDPWR VDPWR sky130_fd_pr__pfet_01v8_hvt ad=0.05775 pd=0.695 as=0.1092 ps=1.36 w=0.42 l=0.15
X641 a_3811_42685# clk VDPWR VDPWR sky130_fd_pr__pfet_01v8_hvt ad=0.1664 pd=1.8 as=0.0864 ps=0.91 w=0.64 l=0.15
X642 VGND clk a_24639_42711# VGND sky130_fd_pr__nfet_01v8 ad=0.0567 pd=0.69 as=0.1092 ps=1.36 w=0.42 l=0.15
X643 VDPWR a_18795_42167# uo_out[1] VDPWR sky130_fd_pr__pfet_01v8_hvt ad=0.26 pd=2.52 as=0.135 ps=1.27 w=1 l=0.15
X644 a_3811_41597# clk VGND VGND sky130_fd_pr__nfet_01v8 ad=0.1092 pd=1.36 as=0.0567 ps=0.69 w=0.42 l=0.15
X645 VDPWR a_9767_43229# uio_out[7] VDPWR sky130_fd_pr__pfet_01v8_hvt ad=0.135 pd=1.27 as=0.135 ps=1.27 w=1 l=0.15
X646 a_3769_43077# a_3431_42863# VDPWR VDPWR sky130_fd_pr__pfet_01v8_hvt ad=0.0882 pd=0.84 as=0.1113 ps=1.37 w=0.42 l=0.15
X647 a_26369_42961# halfP/xq1.A VDPWR VDPWR sky130_fd_pr__pfet_01v8_hvt ad=0.135 pd=1.27 as=0.135 ps=1.27 w=1 l=0.15
X648 VGND a_18390_43229# a_18348_43633# VGND sky130_fd_pr__nfet_01v8 ad=0.12095 pd=1.085 as=0.0696 ps=0.765 w=0.42 l=0.15
X649 a_25246_39965# a_25078_39991# VDPWR VDPWR sky130_fd_pr__pfet_01v8_hvt ad=0.1095 pd=1.075 as=0.17887 ps=1.26 w=0.75 l=0.15
X650 a_15561_42167# halfP/dff2.D VGND VGND sky130_fd_pr__nfet_01v8 ad=0.0813 pd=0.83 as=0.1092 ps=1.36 w=0.42 l=0.15
X651 a_25078_39991# a_24805_39997# a_24993_39991# VDPWR sky130_fd_pr__pfet_01v8_hvt ad=0.06825 pd=0.745 as=0.05775 ps=0.695 w=0.42 l=0.15
X652 a_26369_41623# halfP/xq3.A VGND VGND sky130_fd_pr__nfet_01v8 ad=0.08775 pd=0.92 as=0.08775 ps=0.92 w=0.65 l=0.15
X653 a_3185_41079# halfN/obuf6.A VDPWR VDPWR sky130_fd_pr__pfet_01v8_hvt ad=0.135 pd=1.27 as=0.135 ps=1.27 w=1 l=0.15
X654 a_25246_40647# a_25078_40901# VDPWR VDPWR sky130_fd_pr__pfet_01v8_hvt ad=0.1095 pd=1.075 as=0.17887 ps=1.26 w=0.75 l=0.15
X655 VGND a_10667_43473# a_10674_43377# VGND sky130_fd_pr__nfet_01v8 ad=0.0567 pd=0.69 as=0.1092 ps=1.36 w=0.42 l=0.15
X656 a_24310_24722# VGND halfP/CM1.C2 VDPWR sky130_fd_pr__pfet_01v8 ad=0.1386 pd=1.5 as=0.1386 ps=1.5 w=0.42 l=8
X657 a_17762_42167# a_17489_42173# a_17677_42167# VDPWR sky130_fd_pr__pfet_01v8_hvt ad=0.06825 pd=0.745 as=0.05775 ps=0.695 w=0.42 l=0.15
X658 halfN/RDA.R1_31 halfN/RDA.R2_32 VGND sky130_fd_pr__res_xhigh_po_0p35 l=30.3
X659 a_15833_43261# a_15667_43261# VDPWR VDPWR sky130_fd_pr__pfet_01v8_hvt ad=0.1664 pd=1.8 as=0.0864 ps=0.91 w=0.64 l=0.15
X660 RBT.R1_4 RBT.R2_3 VGND sky130_fd_pr__res_xhigh_po_0p35 l=4.38
X661 halfN/RDA.R1_11 halfN/RDA.R2_10 VGND sky130_fd_pr__res_xhigh_po_0p35 l=30.3
X662 a_18317_43255# a_17783_43261# a_18222_43255# VDPWR sky130_fd_pr__pfet_01v8_hvt ad=0.07665 pd=0.785 as=0.06825 ps=0.745 w=0.42 l=0.15
X663 VDPWR halfN/obuf3.A a_2829_40785# VDPWR sky130_fd_pr__pfet_01v8_hvt ad=0.135 pd=1.27 as=0.135 ps=1.27 w=1 l=0.15
X664 a_25503_40901# a_24805_40535# a_25246_40647# VGND sky130_fd_pr__special_nfet_01v8 ad=0.0684 pd=0.74 as=0.0989 ps=0.995 w=0.36 l=0.15
X665 VDPWR a_11883_43229# uio_out[4] VDPWR sky130_fd_pr__pfet_01v8_hvt ad=0.135 pd=1.27 as=0.135 ps=1.27 w=1 l=0.15
X666 a_16657_43633# a_15667_43261# a_16531_43255# VGND sky130_fd_pr__special_nfet_01v8 ad=0.066 pd=0.745 as=0.0684 ps=0.74 w=0.36 l=0.15
X667 tie_oe4.LO VGND sky130_fd_pr__res_generic_po w=0.48 l=0.5
X668 a_15814_42141# a_15646_42167# VGND VGND sky130_fd_pr__nfet_01v8 ad=0.0989 pd=0.995 as=0.12095 ps=1.085 w=0.64 l=0.15
X669 VGND a_16679_42167# uo_out[5] VGND sky130_fd_pr__nfet_01v8 ad=0.169 pd=1.82 as=0.08775 ps=0.92 w=0.65 l=0.15
X670 VDPWR halfP/obuf6.A a_26201_41079# VDPWR sky130_fd_pr__pfet_01v8_hvt ad=0.135 pd=1.27 as=0.135 ps=1.27 w=1 l=0.15
X671 halfP/RDA.R1_37 halfP/xq6.X VGND sky130_fd_pr__res_xhigh_po_0p35 l=30.3
X672 a_4365_43633# a_3818_43377# a_4018_43532# VDPWR sky130_fd_pr__pfet_01v8_hvt ad=0.05775 pd=0.695 as=0.06825 ps=0.745 w=0.42 l=0.15
X673 a_9767_43229# halfN/obuf5.A VGND VGND sky130_fd_pr__nfet_01v8 ad=0.169 pd=1.82 as=0.08775 ps=0.92 w=0.65 l=0.15
X674 uo_out[3] a_17139_43255# VDPWR VDPWR sky130_fd_pr__pfet_01v8_hvt ad=0.135 pd=1.27 as=0.135 ps=1.27 w=1 l=0.15
X675 a_15887_41989# a_15189_41623# a_15630_41735# VGND sky130_fd_pr__special_nfet_01v8 ad=0.0684 pd=0.74 as=0.0989 ps=0.995 w=0.36 l=0.15
X676 VDPWR a_4018_43532# a_3947_43633# VDPWR sky130_fd_pr__pfet_01v8_hvt ad=0.17887 pd=1.26 as=0.1095 ps=1.075 w=0.75 l=0.15
X677 VGND a_16699_43229# a_16657_43633# VGND sky130_fd_pr__nfet_01v8 ad=0.1092 pd=1.36 as=0.066 ps=0.745 w=0.42 l=0.15
X678 a_13521_42711# a_12967_42685# a_13174_42685# VGND sky130_fd_pr__special_nfet_01v8 ad=0.0813 pd=0.83 as=0.0621 ps=0.705 w=0.36 l=0.15
X679 uio_out[3] a_12067_42685# VDPWR VDPWR sky130_fd_pr__pfet_01v8_hvt ad=0.135 pd=1.27 as=0.26 ps=2.52 w=1 l=0.15
X680 a_10931_41775# a_11027_41597# VGND VGND sky130_fd_pr__nfet_01v8 ad=0.169 pd=1.82 as=0.08775 ps=0.92 w=0.65 l=0.15
X681 a_13139_43621# a_12919_43633# VGND VGND sky130_fd_pr__nfet_01v8 ad=0.0696 pd=0.765 as=0.12095 ps=1.085 w=0.42 l=0.15
X682 a_24805_43261# a_24639_43261# VDPWR VDPWR sky130_fd_pr__pfet_01v8_hvt ad=0.1664 pd=1.8 as=0.0864 ps=0.91 w=0.64 l=0.15
X683 a_19486_39596# a_15306_39570# VDPWR VDPWR sky130_fd_pr__pfet_01v8 ad=0.15 pd=1.3 as=0.33 ps=2.66 w=1 l=1
X684 a_3769_42167# a_3431_42399# VDPWR VDPWR sky130_fd_pr__pfet_01v8_hvt ad=0.0882 pd=0.84 as=0.1113 ps=1.37 w=0.42 l=0.15
X685 halfN/CM1.C2 a_6022_24748# VDPWR VDPWR sky130_fd_pr__pfet_01v8 ad=0.74 pd=4.37 as=0.74 ps=4.37 w=4 l=2
X686 a_24993_42711# halfP/xq1.A VDPWR VDPWR sky130_fd_pr__pfet_01v8_hvt ad=0.05775 pd=0.695 as=0.1092 ps=1.36 w=0.42 l=0.15
X687 VDPWR a_19300_24748# a_19300_24748# VDPWR sky130_fd_pr__pfet_01v8 ad=0.74 pd=4.37 as=0.74 ps=4.37 w=4 l=2
X688 halfN/RDA.R1_41 halfN/RIN.R2_1 VGND sky130_fd_pr__res_xhigh_po_0p35 l=30.3
X689 a_26201_40785# halfP/xq5.B a_26119_40785# VDPWR sky130_fd_pr__pfet_01v8_hvt ad=0.135 pd=1.27 as=0.26 ps=2.52 w=1 l=0.15
X690 a_25629_43633# a_24639_43261# a_25503_43255# VGND sky130_fd_pr__special_nfet_01v8 ad=0.066 pd=0.745 as=0.0684 ps=0.74 w=0.36 l=0.15
X691 a_15649_42711# a_15483_42711# VDPWR VDPWR sky130_fd_pr__pfet_01v8_hvt ad=0.1664 pd=1.8 as=0.0864 ps=0.91 w=0.64 l=0.15
X692 uio_out[0] a_14183_42685# VGND VGND sky130_fd_pr__nfet_01v8 ad=0.08775 pd=0.92 as=0.08775 ps=0.92 w=0.65 l=0.15
X693 a_17489_42173# a_17323_42173# VDPWR VDPWR sky130_fd_pr__pfet_01v8_hvt ad=0.1664 pd=1.8 as=0.0864 ps=0.91 w=0.64 l=0.15
X694 VGND RBT.R2_0 VGND VGND sky130_fd_pr__nfet_01v8 ad=1.65 pd=10.66 as=0 ps=0 w=5 l=10
X695 halfP/xq5.X a_26119_40785# a_26369_40785# VDPWR sky130_fd_pr__pfet_01v8_hvt ad=0.3 pd=2.6 as=0.26 ps=2.52 w=1 l=0.15
X696 VGND a_14839_42711# uo_out[7] VGND sky130_fd_pr__nfet_01v8 ad=0.169 pd=1.82 as=0.08775 ps=0.92 w=0.65 l=0.15
X697 a_4194_41079# a_3947_41457# VDPWR VDPWR sky130_fd_pr__pfet_01v8_hvt ad=0.07665 pd=0.785 as=0.17887 ps=1.26 w=0.42 l=0.15
X698 VDPWR a_12783_43473# a_12790_43377# VDPWR sky130_fd_pr__pfet_01v8_hvt ad=0.0864 pd=0.91 as=0.1664 ps=1.8 w=0.64 l=0.15
X699 a_3017_42711# halfN/xq1.B halfN/xq1.X VGND sky130_fd_pr__nfet_01v8 ad=0.08775 pd=0.92 as=0.25025 ps=1.42 w=0.65 l=0.15
X700 halfN/RDA.R1_29 halfN/RDA.R2_28 VGND sky130_fd_pr__res_xhigh_po_0p35 l=30.3
X701 VGND a_25671_43229# a_25629_43633# VGND sky130_fd_pr__nfet_01v8 ad=0.1092 pd=1.36 as=0.066 ps=0.745 w=0.42 l=0.15
X702 a_13797_42545# a_13250_42289# a_13450_42444# VDPWR sky130_fd_pr__pfet_01v8_hvt ad=0.05775 pd=0.695 as=0.06825 ps=0.745 w=0.42 l=0.15
X703 a_13427_41597# clk VGND VGND sky130_fd_pr__nfet_01v8 ad=0.1092 pd=1.36 as=0.0567 ps=0.69 w=0.42 l=0.15
X704 a_10803_43633# a_10674_43377# a_10383_43487# VGND sky130_fd_pr__special_nfet_01v8 ad=0.0989 pd=0.995 as=0.0684 ps=0.74 w=0.36 l=0.15
X705 a_25204_42711# a_24805_42711# a_25078_43077# VGND sky130_fd_pr__special_nfet_01v8 ad=0.0696 pd=0.765 as=0.0621 ps=0.705 w=0.36 l=0.15
X706 VDPWR a_13450_42444# a_13379_42545# VDPWR sky130_fd_pr__pfet_01v8_hvt ad=0.17887 pd=1.26 as=0.1095 ps=1.075 w=0.75 l=0.15
X707 halfP/RIN.R2_1 halfP/CM1.C2 sky130_fd_pr__cap_mim_m3_1 l=25 w=24
X708 halfP/RDA.R1_1 halfP/xq0.X VGND sky130_fd_pr__res_xhigh_po_0p35 l=30.3
X709 VDPWR halfN/obuf3.A a_4365_40535# VDPWR sky130_fd_pr__pfet_01v8_hvt ad=0.1092 pd=1.36 as=0.05775 ps=0.695 w=0.42 l=0.15
X710 VDPWR halfN/dff4.D a_13337_43633# VDPWR sky130_fd_pr__pfet_01v8_hvt ad=0.1092 pd=1.36 as=0.05775 ps=0.695 w=0.42 l=0.15
X711 halfP/dff2.D halfP/dff1.D a_18046_39236# VGND sky130_fd_pr__nfet_01v8 ad=0.165 pd=1.66 as=0.075 ps=0.8 w=0.5 l=0.15
X712 VGND a_3811_43473# a_3818_43377# VGND sky130_fd_pr__nfet_01v8 ad=0.0567 pd=0.69 as=0.1092 ps=1.36 w=0.42 l=0.15
X713 a_18137_43255# halfP/dff5.D VDPWR VDPWR sky130_fd_pr__pfet_01v8_hvt ad=0.05775 pd=0.695 as=0.1092 ps=1.36 w=0.42 l=0.15
X714 uo_out[1] a_18795_42167# VDPWR VDPWR sky130_fd_pr__pfet_01v8_hvt ad=0.135 pd=1.27 as=0.135 ps=1.27 w=1 l=0.15
X715 uio_out[7] a_9767_43229# VDPWR VDPWR sky130_fd_pr__pfet_01v8_hvt ad=0.135 pd=1.27 as=0.26 ps=2.52 w=1 l=0.15
X716 VGND a_18355_42141# a_18313_42545# VGND sky130_fd_pr__nfet_01v8 ad=0.1092 pd=1.36 as=0.066 ps=0.745 w=0.42 l=0.15
X717 halfP/xq2.X halfP/xq2.B a_26369_42487# VGND sky130_fd_pr__nfet_01v8 ad=0.25025 pd=1.42 as=0.08775 ps=0.92 w=0.65 l=0.15
X718 a_13634_41597# a_13434_41897# a_13783_41623# VGND sky130_fd_pr__special_nfet_01v8 ad=0.0621 pd=0.705 as=0.0696 ps=0.765 w=0.36 l=0.15
X719 a_4018_41356# a_3811_41297# a_4194_41079# VDPWR sky130_fd_pr__pfet_01v8_hvt ad=0.06825 pd=0.745 as=0.07665 ps=0.785 w=0.42 l=0.15
X720 halfP/RDA.R1_13 halfP/RDA.R2_14 VGND sky130_fd_pr__res_xhigh_po_0p35 l=30.3
X721 halfP/RDA.R1_0 VGND VGND sky130_fd_pr__res_xhigh_po_0p35 l=30.3
X722 VDPWR a_11883_43229# uio_out[4] VDPWR sky130_fd_pr__pfet_01v8_hvt ad=0.135 pd=1.27 as=0.135 ps=1.27 w=1 l=0.15
X723 uo_out[0] a_19255_43255# VGND VGND sky130_fd_pr__nfet_01v8 ad=0.08775 pd=0.92 as=0.08775 ps=0.92 w=0.65 l=0.15
X724 a_4167_40357# a_3947_40369# VGND VGND sky130_fd_pr__nfet_01v8 ad=0.0696 pd=0.765 as=0.12095 ps=1.085 w=0.42 l=0.15
X725 VDPWR a_10931_41775# halfN/xq2.A VDPWR sky130_fd_pr__pfet_01v8_hvt ad=0.135 pd=1.27 as=0.26 ps=2.52 w=1 l=0.15
X726 a_17704_41623# a_17305_41623# a_17578_41989# VGND sky130_fd_pr__special_nfet_01v8 ad=0.0696 pd=0.765 as=0.0621 ps=0.705 w=0.36 l=0.15
X727 VGND a_26119_41873# halfP/xq3.X VGND sky130_fd_pr__nfet_01v8 ad=0.208 pd=1.94 as=0.25025 ps=1.42 w=0.65 l=0.15
X728 VDPWR clk a_15667_43261# VDPWR sky130_fd_pr__pfet_01v8_hvt ad=0.0864 pd=0.91 as=0.1664 ps=1.8 w=0.64 l=0.15
X729 halfN/CM1.C2 halfN/RIN.R2_1 a_5356_24748# VGND sky130_fd_pr__nfet_01v8 ad=2.22 pd=12.37 as=2.22 ps=12.37 w=12 l=3
X730 VGND a_10874_43532# a_10803_43633# VGND sky130_fd_pr__nfet_01v8 ad=0.12095 pd=1.085 as=0.0989 ps=0.995 w=0.64 l=0.15
X731 uio_out[1] a_12527_41597# VDPWR VDPWR sky130_fd_pr__pfet_01v8_hvt ad=0.135 pd=1.27 as=0.135 ps=1.27 w=1 l=0.15
X732 halfP/xq5.B a_25671_40803# VGND VGND sky130_fd_pr__nfet_01v8 ad=0.169 pd=1.82 as=0.08775 ps=0.92 w=0.65 l=0.15
X733 a_3527_40509# a_3811_40509# a_3746_40535# VGND sky130_fd_pr__special_nfet_01v8 ad=0.0684 pd=0.74 as=0.066 ps=0.745 w=0.36 l=0.15
X734 halfP/obuf6.A a_16515_42979# VDPWR VDPWR sky130_fd_pr__pfet_01v8_hvt ad=0.26 pd=2.52 as=0.135 ps=1.27 w=1 l=0.15
X735 a_24993_42167# halfP/xq2.A VDPWR VDPWR sky130_fd_pr__pfet_01v8_hvt ad=0.05775 pd=0.695 as=0.1092 ps=1.36 w=0.42 l=0.15
X736 VDPWR a_15887_41989# a_16055_41891# VDPWR sky130_fd_pr__pfet_01v8_hvt ad=0.135 pd=1.27 as=0.27 ps=2.54 w=1 l=0.15
X737 a_2799_42896# halfN/xq1.A VGND VGND sky130_fd_pr__nfet_01v8 ad=0.08775 pd=0.92 as=0.08775 ps=0.92 w=0.65 l=0.15
X738 a_13178_42533# a_12863_42399# VGND VGND sky130_fd_pr__nfet_01v8 ad=0.066 pd=0.745 as=0.1092 ps=1.36 w=0.42 l=0.15
X739 a_25503_39991# a_24805_39997# a_25246_39965# VGND sky130_fd_pr__special_nfet_01v8 ad=0.0684 pd=0.74 as=0.0989 ps=0.995 w=0.36 l=0.15
X740 a_10667_43473# clk VDPWR VDPWR sky130_fd_pr__pfet_01v8_hvt ad=0.1664 pd=1.8 as=0.0864 ps=0.91 w=0.64 l=0.15
X741 a_16090_42823# a_15922_43077# VGND VGND sky130_fd_pr__nfet_01v8 ad=0.0989 pd=0.995 as=0.12095 ps=1.085 w=0.64 l=0.15
X742 halfN/CM1.C2 a_6022_24748# VDPWR VDPWR sky130_fd_pr__pfet_01v8 ad=0.74 pd=4.37 as=0.74 ps=4.37 w=4 l=2
X743 VGND a_3431_40687# halfN/xq5.B VGND sky130_fd_pr__nfet_01v8 ad=0.08775 pd=0.92 as=0.169 ps=1.82 w=0.65 l=0.15
X744 VGND a_9767_43229# uio_out[7] VGND sky130_fd_pr__nfet_01v8 ad=0.08775 pd=0.92 as=0.08775 ps=0.92 w=0.65 l=0.15
X745 VDPWR a_17139_43255# uo_out[3] VDPWR sky130_fd_pr__pfet_01v8_hvt ad=0.135 pd=1.27 as=0.135 ps=1.27 w=1 l=0.15
X746 a_15922_43077# a_15483_42711# a_15837_42711# VGND sky130_fd_pr__special_nfet_01v8 ad=0.0621 pd=0.705 as=0.0813 ps=0.83 w=0.36 l=0.15
X747 VGND a_25671_42979# a_25629_42711# VGND sky130_fd_pr__nfet_01v8 ad=0.1092 pd=1.36 as=0.066 ps=0.745 w=0.42 l=0.15
X748 a_24310_24722# halfP/CM1.C2 a_24310_24722# VGND sky130_fd_pr__nfet_01v8 ad=1.32 pd=8.66 as=2.7786 ps=18.82 w=4 l=3
X749 a_17026_24748# RBT.R2_0 a_19300_24748# VGND sky130_fd_pr__nfet_01v8 ad=3.96 pd=24.66 as=2.22 ps=12.37 w=12 l=3
X750 halfP/RDA.R1_25 halfP/RDA.R2_26 VGND sky130_fd_pr__res_xhigh_po_0p35 l=30.3
X751 halfN/RIN.R2_1 halfN/CM1.C2 sky130_fd_pr__cap_mim_m3_1 l=25 w=24
X752 VGND a_3811_42685# a_3818_42985# VGND sky130_fd_pr__nfet_01v8 ad=0.0567 pd=0.69 as=0.1092 ps=1.36 w=0.42 l=0.15
X753 a_3947_41623# a_3811_41597# a_3527_41597# VDPWR sky130_fd_pr__pfet_01v8_hvt ad=0.1095 pd=1.075 as=0.0567 ps=0.69 w=0.42 l=0.15
X754 VDPWR a_25671_40803# a_25587_40901# VDPWR sky130_fd_pr__pfet_01v8_hvt ad=0.1113 pd=1.37 as=0.0882 ps=0.84 w=0.42 l=0.15
X755 a_10383_43487# a_10674_43377# a_10625_43255# VDPWR sky130_fd_pr__pfet_01v8_hvt ad=0.0567 pd=0.69 as=0.0882 ps=0.84 w=0.42 l=0.15
X756 a_3947_43633# a_3818_43377# a_3527_43487# VGND sky130_fd_pr__special_nfet_01v8 ad=0.0989 pd=0.995 as=0.0684 ps=0.74 w=0.36 l=0.15
X757 VGND halfN/xq2.B a_2799_42141# VGND sky130_fd_pr__nfet_01v8 ad=0.169 pd=1.82 as=0.08775 ps=0.92 w=0.65 l=0.15
X758 halfN/xq2.X a_2799_42141# VGND VGND sky130_fd_pr__nfet_01v8 ad=0.25025 pd=1.42 as=0.208 ps=1.94 w=0.65 l=0.15
X759 uio_out[2] a_12343_42141# VDPWR VDPWR sky130_fd_pr__pfet_01v8_hvt ad=0.135 pd=1.27 as=0.135 ps=1.27 w=1 l=0.15
X760 halfP/dff2.D halfP/dff1.D a_18046_39596# VDPWR sky130_fd_pr__pfet_01v8 ad=0.33 pd=2.66 as=0.15 ps=1.3 w=1 l=0.15
X761 VGND a_14183_42685# uio_out[0] VGND sky130_fd_pr__nfet_01v8 ad=0.08775 pd=0.92 as=0.08775 ps=0.92 w=0.65 l=0.15
X762 VGND halfP/xq1.A a_26119_42961# VGND sky130_fd_pr__nfet_01v8 ad=0.08775 pd=0.92 as=0.08775 ps=0.92 w=0.65 l=0.15
X763 a_25587_41989# a_24805_41623# a_25503_41989# VDPWR sky130_fd_pr__pfet_01v8_hvt ad=0.0882 pd=0.84 as=0.0567 ps=0.69 w=0.42 l=0.15
X764 a_2829_42961# a_2799_42896# halfN/xq1.X VDPWR sky130_fd_pr__pfet_01v8_hvt ad=0.26 pd=2.52 as=0.3 ps=2.6 w=1 l=0.15
X765 VDPWR halfN/xq2.A a_2829_42167# VDPWR sky130_fd_pr__pfet_01v8_hvt ad=0.135 pd=1.27 as=0.135 ps=1.27 w=1 l=0.15
X766 VGND a_13634_41597# a_13563_41623# VGND sky130_fd_pr__nfet_01v8 ad=0.12095 pd=1.085 as=0.0989 ps=0.995 w=0.64 l=0.15
X767 a_17305_41623# a_17139_41623# VGND VGND sky130_fd_pr__nfet_01v8 ad=0.1092 pd=1.36 as=0.0567 ps=0.69 w=0.42 l=0.15
X768 VGND RB.R2_1 a_5356_24748# VGND sky130_fd_pr__nfet_01v8 ad=0.66 pd=4.66 as=0.37 ps=2.37 w=2 l=2
X769 VGND tie_oe3.LO sky130_fd_pr__res_generic_po w=0.48 l=0.5
X770 a_11483_42533# a_11263_42545# VGND VGND sky130_fd_pr__nfet_01v8 ad=0.0696 pd=0.765 as=0.12095 ps=1.085 w=0.42 l=0.15
X771 halfP/dff4.D halfP/mon.A a_17086_39236# VGND sky130_fd_pr__nfet_01v8 ad=0.165 pd=1.66 as=0.075 ps=0.8 w=0.5 l=0.15
X772 a_25204_42545# a_24805_42173# a_25078_42167# VGND sky130_fd_pr__special_nfet_01v8 ad=0.0696 pd=0.765 as=0.0621 ps=0.705 w=0.36 l=0.15
X773 a_4365_41623# a_3811_41597# a_4018_41597# VGND sky130_fd_pr__special_nfet_01v8 ad=0.0813 pd=0.83 as=0.0621 ps=0.705 w=0.36 l=0.15
X774 VGND halfP/mon.A VGND VGND sky130_fd_pr__nfet_01v8 ad=0.49 pd=3.5 as=0 ps=0 w=1.4 l=2.86
X775 VDPWR uio_oe[0] sky130_fd_pr__res_generic_po w=0.48 l=0.5
X776 uo_out[1] a_18795_42167# VDPWR VDPWR sky130_fd_pr__pfet_01v8_hvt ad=0.135 pd=1.27 as=0.135 ps=1.27 w=1 l=0.15
X777 a_26369_42487# halfP/xq2.A VGND VGND sky130_fd_pr__nfet_01v8 ad=0.08775 pd=0.92 as=0.08775 ps=0.92 w=0.65 l=0.15
X778 VGND halfN/xq2.A a_4365_42545# VGND sky130_fd_pr__nfet_01v8 ad=0.1092 pd=1.36 as=0.0813 ps=0.83 w=0.42 l=0.15
X779 a_16071_42167# a_15373_42173# a_15814_42141# VGND sky130_fd_pr__special_nfet_01v8 ad=0.0684 pd=0.74 as=0.0989 ps=0.995 w=0.36 l=0.15
X780 a_26201_42167# halfP/xq2.B a_26119_42167# VDPWR sky130_fd_pr__pfet_01v8_hvt ad=0.135 pd=1.27 as=0.26 ps=2.52 w=1 l=0.15
X781 halfP/RDA.R1_29 halfP/RDA.R2_28 VGND sky130_fd_pr__res_xhigh_po_0p35 l=30.3
X782 VDPWR a_11127_42385# a_11134_42289# VDPWR sky130_fd_pr__pfet_01v8_hvt ad=0.0864 pd=0.91 as=0.1664 ps=1.8 w=0.64 l=0.15
X783 halfP/xq2.X a_26119_42167# a_26369_42167# VDPWR sky130_fd_pr__pfet_01v8_hvt ad=0.3 pd=2.6 as=0.26 ps=2.52 w=1 l=0.15
X784 VDPWR a_6022_24748# halfN/CM1.C2 VDPWR sky130_fd_pr__pfet_01v8 ad=0.74 pd=4.37 as=0.74 ps=4.37 w=4 l=2
X785 VGND clk a_24639_39997# VGND sky130_fd_pr__nfet_01v8 ad=0.0567 pd=0.69 as=0.1092 ps=1.36 w=0.42 l=0.15
X786 a_3811_43473# clk VDPWR VDPWR sky130_fd_pr__pfet_01v8_hvt ad=0.1664 pd=1.8 as=0.0864 ps=0.91 w=0.64 l=0.15
X787 VDPWR halfN/dff3.D a_11681_42545# VDPWR sky130_fd_pr__pfet_01v8_hvt ad=0.1092 pd=1.36 as=0.05775 ps=0.695 w=0.42 l=0.15
X788 a_13810_41989# a_13563_41623# VDPWR VDPWR sky130_fd_pr__pfet_01v8_hvt ad=0.07665 pd=0.785 as=0.17887 ps=1.26 w=0.42 l=0.15
X789 a_16274_43229# a_16106_43255# VDPWR VDPWR sky130_fd_pr__pfet_01v8_hvt ad=0.1095 pd=1.075 as=0.17887 ps=1.26 w=0.75 l=0.15
X790 VGND a_16495_41623# uo_out[6] VGND sky130_fd_pr__nfet_01v8 ad=0.08775 pd=0.92 as=0.08775 ps=0.92 w=0.65 l=0.15
X791 a_3527_40223# a_3811_40209# a_3746_40357# VGND sky130_fd_pr__special_nfet_01v8 ad=0.0684 pd=0.74 as=0.066 ps=0.745 w=0.36 l=0.15
X792 VGND clk a_15483_42711# VGND sky130_fd_pr__nfet_01v8 ad=0.0567 pd=0.69 as=0.1092 ps=1.36 w=0.42 l=0.15
X793 a_13634_41597# a_13427_41597# a_13810_41989# VDPWR sky130_fd_pr__pfet_01v8_hvt ad=0.06825 pd=0.745 as=0.07665 ps=0.785 w=0.42 l=0.15
X794 a_10602_43621# a_10287_43487# VGND VGND sky130_fd_pr__nfet_01v8 ad=0.066 pd=0.745 as=0.1092 ps=1.36 w=0.42 l=0.15
X795 a_16017_43077# a_15483_42711# a_15922_43077# VDPWR sky130_fd_pr__pfet_01v8_hvt ad=0.07665 pd=0.785 as=0.06825 ps=0.745 w=0.42 l=0.15
X796 a_13563_41623# a_13427_41597# a_13143_41597# VDPWR sky130_fd_pr__pfet_01v8_hvt ad=0.1095 pd=1.075 as=0.0567 ps=0.69 w=0.42 l=0.15
X797 a_19300_24748# RBT.R2_0 a_17026_24748# VGND sky130_fd_pr__nfet_01v8 ad=2.22 pd=12.37 as=3.96 ps=24.66 w=12 l=3
X798 uo_out[5] a_16679_42167# VGND VGND sky130_fd_pr__nfet_01v8 ad=0.08775 pd=0.92 as=0.08775 ps=0.92 w=0.65 l=0.15
X799 VGND a_3464_26480# halfN/CM1.C2 VGND sky130_fd_pr__nfet_01v8 ad=0.99 pd=6.66 as=0.555 ps=3.37 w=3 l=0.5
X800 a_5356_24748# RB.R2_1 VGND VGND sky130_fd_pr__nfet_01v8 ad=0.37 pd=2.37 as=0.37 ps=2.37 w=2 l=2
X801 RT.R1_2 RT.R2_3 VGND sky130_fd_pr__res_xhigh_po_0p35 l=4.38
X802 halfN/RDA.R1_15 halfN/RDA.R2_14 VGND sky130_fd_pr__res_xhigh_po_0p35 l=30.3
X803 halfP/dff1.D halfP/dff4.D a_17566_39236# VGND sky130_fd_pr__nfet_01v8 ad=0.165 pd=1.66 as=0.075 ps=0.8 w=0.5 l=0.15
X804 a_25629_40535# a_24639_40535# a_25503_40901# VGND sky130_fd_pr__special_nfet_01v8 ad=0.066 pd=0.745 as=0.0684 ps=0.74 w=0.36 l=0.15
X805 a_10747_42399# a_10843_42399# VGND VGND sky130_fd_pr__nfet_01v8 ad=0.169 pd=1.82 as=0.08775 ps=0.92 w=0.65 l=0.15
X806 VGND halfP/dff4.D VGND VGND sky130_fd_pr__nfet_01v8 ad=0.49 pd=3.5 as=0 ps=0 w=1.4 l=2.86
X807 a_11311_41597# clk VDPWR VDPWR sky130_fd_pr__pfet_01v8_hvt ad=0.1664 pd=1.8 as=0.0864 ps=0.91 w=0.64 l=0.15
X808 a_25246_43229# a_25078_43255# VDPWR VDPWR sky130_fd_pr__pfet_01v8_hvt ad=0.1095 pd=1.075 as=0.17887 ps=1.26 w=0.75 l=0.15
X809 a_11269_41989# a_10931_41775# VDPWR VDPWR sky130_fd_pr__pfet_01v8_hvt ad=0.0882 pd=0.84 as=0.1113 ps=1.37 w=0.42 l=0.15
X810 halfP/dff4.D halfP/mon.A a_17086_39596# VDPWR sky130_fd_pr__pfet_01v8 ad=0.33 pd=2.66 as=0.15 ps=1.3 w=1 l=0.15
X811 a_3017_43575# halfN/xq0.B halfN/xq0.X VGND sky130_fd_pr__nfet_01v8 ad=0.08775 pd=0.92 as=0.25025 ps=1.42 w=0.65 l=0.15
X812 a_25078_43255# a_24805_43261# a_24993_43255# VDPWR sky130_fd_pr__pfet_01v8_hvt ad=0.06825 pd=0.745 as=0.05775 ps=0.695 w=0.42 l=0.15
X813 a_10931_41775# a_11027_41597# VDPWR VDPWR sky130_fd_pr__pfet_01v8_hvt ad=0.27 pd=2.54 as=0.135 ps=1.27 w=1 l=0.15
X814 VGND halfN/xq3.A a_4365_41623# VGND sky130_fd_pr__nfet_01v8 ad=0.1092 pd=1.36 as=0.0813 ps=0.83 w=0.42 l=0.15
X815 VDPWR a_12343_42141# uio_out[2] VDPWR sky130_fd_pr__pfet_01v8_hvt ad=0.135 pd=1.27 as=0.135 ps=1.27 w=1 l=0.15
X816 a_15833_43261# a_15667_43261# VGND VGND sky130_fd_pr__nfet_01v8 ad=0.1092 pd=1.36 as=0.0567 ps=0.69 w=0.42 l=0.15
X817 halfN/CM1.C2 a_3464_26480# VGND VGND sky130_fd_pr__nfet_01v8 ad=0.555 pd=3.37 as=0.99 ps=6.66 w=3 l=0.5
X818 VDPWR uio_oe[4] sky130_fd_pr__res_generic_po w=0.48 l=0.5
X819 a_14183_42685# halfN/mon.A VDPWR VDPWR sky130_fd_pr__pfet_01v8_hvt ad=0.26 pd=2.52 as=0.135 ps=1.27 w=1 l=0.15
X820 a_3431_40223# a_3527_40223# VGND VGND sky130_fd_pr__nfet_01v8 ad=0.169 pd=1.82 as=0.08775 ps=0.92 w=0.65 l=0.15
X821 a_12343_42141# halfN/xq3.A VDPWR VDPWR sky130_fd_pr__pfet_01v8_hvt ad=0.26 pd=2.52 as=0.135 ps=1.27 w=1 l=0.15
X822 a_4365_40535# a_3818_40809# a_4018_40509# VDPWR sky130_fd_pr__pfet_01v8_hvt ad=0.05775 pd=0.695 as=0.06825 ps=0.745 w=0.42 l=0.15
X823 a_13337_43633# a_12790_43377# a_12990_43532# VDPWR sky130_fd_pr__pfet_01v8_hvt ad=0.05775 pd=0.695 as=0.06825 ps=0.745 w=0.42 l=0.15
X824 halfN/RDA.R1_7 halfN/xq1.X VGND sky130_fd_pr__res_xhigh_po_0p35 l=30.3
X825 VDPWR a_12990_43532# a_12919_43633# VDPWR sky130_fd_pr__pfet_01v8_hvt ad=0.17887 pd=1.26 as=0.1095 ps=1.075 w=0.75 l=0.15
X826 VGND a_25503_41989# a_25671_41891# VGND sky130_fd_pr__nfet_01v8 ad=0.08775 pd=0.92 as=0.169 ps=1.82 w=0.65 l=0.15
X827 a_6022_24748# RBT.R2_0 a_5356_24748# VGND sky130_fd_pr__nfet_01v8 ad=2.22 pd=12.37 as=2.22 ps=12.37 w=12 l=3
X828 a_4365_41457# a_3811_41297# a_4018_41356# VGND sky130_fd_pr__special_nfet_01v8 ad=0.0813 pd=0.83 as=0.0621 ps=0.705 w=0.36 l=0.15
X829 VGND RB.R2_1 RB.R2_1 VGND sky130_fd_pr__nfet_01v8 ad=0.37 pd=2.37 as=0.37 ps=2.37 w=2 l=2
X830 halfN/RDA.R1_7 halfN/RDA.R2_8 VGND sky130_fd_pr__res_xhigh_po_0p35 l=30.3
X831 halfN/RDA.R1_43 VGND VGND sky130_fd_pr__res_xhigh_po_0p35 l=30.3
X832 a_16106_43255# a_15667_43261# a_16021_43255# VGND sky130_fd_pr__special_nfet_01v8 ad=0.0621 pd=0.705 as=0.0813 ps=0.83 w=0.36 l=0.15
X833 VDPWR halfP/obuf3.A a_18795_42167# VDPWR sky130_fd_pr__pfet_01v8_hvt ad=0.135 pd=1.27 as=0.26 ps=2.52 w=1 l=0.15
X834 VGND a_26119_42167# halfP/xq2.X VGND sky130_fd_pr__nfet_01v8 ad=0.208 pd=1.94 as=0.25025 ps=1.42 w=0.65 l=0.15
X835 a_24805_43261# a_24639_43261# VGND VGND sky130_fd_pr__nfet_01v8 ad=0.1092 pd=1.36 as=0.0567 ps=0.69 w=0.42 l=0.15
X836 RT.R1_6 RT.R2_5 VGND sky130_fd_pr__res_xhigh_po_0p35 l=4.38
X837 a_15837_42711# halfP/dff6.D VDPWR VDPWR sky130_fd_pr__pfet_01v8_hvt ad=0.05775 pd=0.695 as=0.1092 ps=1.36 w=0.42 l=0.15
X838 a_3746_43621# a_3431_43487# VGND VGND sky130_fd_pr__nfet_01v8 ad=0.066 pd=0.745 as=0.1092 ps=1.36 w=0.42 l=0.15
X839 a_11263_42545# a_11134_42289# a_10843_42399# VGND sky130_fd_pr__special_nfet_01v8 ad=0.0989 pd=0.995 as=0.0684 ps=0.74 w=0.36 l=0.15
X840 a_3947_41457# a_3811_41297# a_3527_41311# VDPWR sky130_fd_pr__pfet_01v8_hvt ad=0.1095 pd=1.075 as=0.0567 ps=0.69 w=0.42 l=0.15
X841 halfP/xq4.B a_25671_41053# VGND VGND sky130_fd_pr__nfet_01v8 ad=0.169 pd=1.82 as=0.08775 ps=0.92 w=0.65 l=0.15
X842 halfP/xq4.B a_25671_41053# VDPWR VDPWR sky130_fd_pr__pfet_01v8_hvt ad=0.26 pd=2.52 as=0.135 ps=1.27 w=1 l=0.15
X843 halfP/RDA.R1_39 halfP/RDA.R2_40 VGND sky130_fd_pr__res_xhigh_po_0p35 l=30.3
X844 a_17489_42173# a_17323_42173# VGND VGND sky130_fd_pr__nfet_01v8 ad=0.1092 pd=1.36 as=0.0567 ps=0.69 w=0.42 l=0.15
X845 VDPWR halfP/xq4.B a_26369_41079# VDPWR sky130_fd_pr__pfet_01v8_hvt ad=0.26 pd=2.52 as=0.135 ps=1.27 w=1 l=0.15
X846 halfP/dff1.D halfP/dff4.D a_17566_39596# VDPWR sky130_fd_pr__pfet_01v8 ad=0.33 pd=2.66 as=0.15 ps=1.3 w=1 l=0.15
X847 a_16048_42711# a_15649_42711# a_15922_43077# VGND sky130_fd_pr__special_nfet_01v8 ad=0.0696 pd=0.765 as=0.0621 ps=0.705 w=0.36 l=0.15
X848 a_2799_43229# halfN/xq0.A VGND VGND sky130_fd_pr__nfet_01v8 ad=0.08775 pd=0.92 as=0.08775 ps=0.92 w=0.65 l=0.15
X849 VGND a_12783_43473# a_12790_43377# VGND sky130_fd_pr__nfet_01v8 ad=0.0567 pd=0.69 as=0.1092 ps=1.36 w=0.42 l=0.15
X850 uio_out[3] a_12067_42685# VDPWR VDPWR sky130_fd_pr__pfet_01v8_hvt ad=0.135 pd=1.27 as=0.135 ps=1.27 w=1 l=0.15
X851 VGND a_16274_43229# a_16232_43633# VGND sky130_fd_pr__nfet_01v8 ad=0.12095 pd=1.085 as=0.0696 ps=0.765 w=0.42 l=0.15
X852 a_25078_43255# a_24639_43261# a_24993_43255# VGND sky130_fd_pr__special_nfet_01v8 ad=0.0621 pd=0.705 as=0.0813 ps=0.83 w=0.36 l=0.15
X853 a_4018_42685# a_3818_42985# a_4167_42711# VGND sky130_fd_pr__special_nfet_01v8 ad=0.0621 pd=0.705 as=0.0696 ps=0.765 w=0.36 l=0.15
X854 uio_out[6] a_10227_42141# VDPWR VDPWR sky130_fd_pr__pfet_01v8_hvt ad=0.135 pd=1.27 as=0.135 ps=1.27 w=1 l=0.15
X855 VGND a_3431_41311# halfN/xq4.B VGND sky130_fd_pr__nfet_01v8 ad=0.08775 pd=0.92 as=0.169 ps=1.82 w=0.65 l=0.15
X856 a_3431_41311# a_3527_41311# VDPWR VDPWR sky130_fd_pr__pfet_01v8_hvt ad=0.27 pd=2.54 as=0.135 ps=1.27 w=1 l=0.15
X857 a_25587_41079# a_24805_41085# a_25503_41079# VDPWR sky130_fd_pr__pfet_01v8_hvt ad=0.0882 pd=0.84 as=0.0567 ps=0.69 w=0.42 l=0.15
X858 halfP/obuf5.A a_18815_43229# VGND VGND sky130_fd_pr__nfet_01v8 ad=0.169 pd=1.82 as=0.08775 ps=0.92 w=0.65 l=0.15
X859 VDPWR a_4018_41597# a_3947_41623# VDPWR sky130_fd_pr__pfet_01v8_hvt ad=0.17887 pd=1.26 as=0.1095 ps=1.075 w=0.75 l=0.15
X860 a_3769_39991# a_3431_40223# VDPWR VDPWR sky130_fd_pr__pfet_01v8_hvt ad=0.0882 pd=0.84 as=0.1113 ps=1.37 w=0.42 l=0.15
X861 VDPWR a_25503_40901# a_25671_40803# VDPWR sky130_fd_pr__pfet_01v8_hvt ad=0.135 pd=1.27 as=0.27 ps=2.54 w=1 l=0.15
X862 VDPWR a_16955_42711# uo_out[4] VDPWR sky130_fd_pr__pfet_01v8_hvt ad=0.135 pd=1.27 as=0.135 ps=1.27 w=1 l=0.15
X863 a_13143_41597# a_13434_41897# a_13385_41989# VDPWR sky130_fd_pr__pfet_01v8_hvt ad=0.0567 pd=0.69 as=0.0882 ps=0.84 w=0.42 l=0.15
X864 a_15377_41623# halfP/mon.A VGND VGND sky130_fd_pr__nfet_01v8 ad=0.0813 pd=0.83 as=0.1092 ps=1.36 w=0.42 l=0.15
X865 halfN/RDA.R1_3 halfN/RDA.R2_4 VGND sky130_fd_pr__res_xhigh_po_0p35 l=30.3
X866 halfN/RDA.R1_39 halfN/RDA.R2_38 VGND sky130_fd_pr__res_xhigh_po_0p35 l=30.3
X867 halfP/mon.A halfP/dff5.D a_16606_39236# VGND sky130_fd_pr__nfet_01v8 ad=0.165 pd=1.66 as=0.075 ps=0.8 w=0.5 l=0.15
X868 VGND halfN/obuf5.A a_3017_40311# VGND sky130_fd_pr__nfet_01v8 ad=0.08775 pd=0.92 as=0.08775 ps=0.92 w=0.65 l=0.15
X869 a_3947_40535# a_3818_40809# a_3527_40509# VGND sky130_fd_pr__special_nfet_01v8 ad=0.0989 pd=0.995 as=0.0684 ps=0.74 w=0.36 l=0.15
X870 a_10383_43487# a_10667_43473# a_10602_43621# VGND sky130_fd_pr__special_nfet_01v8 ad=0.0684 pd=0.74 as=0.066 ps=0.745 w=0.36 l=0.15
X871 VGND RBT.R2_0 VGND VGND sky130_fd_pr__nfet_01v8 ad=0.925 pd=5.37 as=0 ps=0 w=5 l=10
X872 a_2829_40785# halfN/xq5.B VDPWR VDPWR sky130_fd_pr__pfet_01v8_hvt ad=0.135 pd=1.27 as=0.26 ps=2.52 w=1 l=0.15
X873 halfN/RDA.R1_25 halfN/RDA.R2_26 VGND sky130_fd_pr__res_xhigh_po_0p35 l=30.3
X874 VGND a_10747_42399# halfN/obuf3.A VGND sky130_fd_pr__nfet_01v8 ad=0.08775 pd=0.92 as=0.169 ps=1.82 w=0.65 l=0.15
X875 a_15189_41623# a_15023_41623# VDPWR VDPWR sky130_fd_pr__pfet_01v8_hvt ad=0.1664 pd=1.8 as=0.0864 ps=0.91 w=0.64 l=0.15
X876 VGND halfN/mon.A a_13981_41623# VGND sky130_fd_pr__nfet_01v8 ad=0.1092 pd=1.36 as=0.0813 ps=0.83 w=0.42 l=0.15
X877 VDPWR a_3431_40687# halfN/xq5.B VDPWR sky130_fd_pr__pfet_01v8_hvt ad=0.135 pd=1.27 as=0.26 ps=2.52 w=1 l=0.15
X878 halfN/RDA.R1_5 halfN/RDA.R2_4 VGND sky130_fd_pr__res_xhigh_po_0p35 l=30.3
X879 halfN/RDA.R1_39 halfN/RDA.R2_40 VGND sky130_fd_pr__res_xhigh_po_0p35 l=30.3
X880 a_25629_40369# a_24639_39997# a_25503_39991# VGND sky130_fd_pr__special_nfet_01v8 ad=0.066 pd=0.745 as=0.0684 ps=0.74 w=0.36 l=0.15
X881 a_16201_43255# a_15667_43261# a_16106_43255# VDPWR sky130_fd_pr__pfet_01v8_hvt ad=0.07665 pd=0.785 as=0.06825 ps=0.745 w=0.42 l=0.15
X882 VGND a_11334_42444# a_11263_42545# VGND sky130_fd_pr__nfet_01v8 ad=0.12095 pd=1.085 as=0.0989 ps=0.995 w=0.64 l=0.15
X883 a_18003_41989# a_17139_41623# a_17746_41735# VDPWR sky130_fd_pr__pfet_01v8_hvt ad=0.0567 pd=0.69 as=0.1095 ps=1.075 w=0.42 l=0.15
X884 halfN/CM1.C2 VGND a_3464_26480# VDPWR sky130_fd_pr__pfet_01v8 ad=0.1386 pd=1.5 as=0.1386 ps=1.5 w=0.42 l=8
X885 a_3464_26480# halfN/CM1.C2 a_3464_26480# VGND sky130_fd_pr__nfet_01v8 ad=1.32 pd=8.66 as=2.7786 ps=18.82 w=4 l=3
X886 a_12741_43255# a_12403_43487# VDPWR VDPWR sky130_fd_pr__pfet_01v8_hvt ad=0.0882 pd=0.84 as=0.1113 ps=1.37 w=0.42 l=0.15
X887 VGND halfP/xq0.A a_26119_43255# VGND sky130_fd_pr__nfet_01v8 ad=0.08775 pd=0.92 as=0.08775 ps=0.92 w=0.65 l=0.15
X888 VDPWR a_18795_42167# uo_out[1] VDPWR sky130_fd_pr__pfet_01v8_hvt ad=0.135 pd=1.27 as=0.135 ps=1.27 w=1 l=0.15
X889 a_17673_41989# a_17139_41623# a_17578_41989# VDPWR sky130_fd_pr__pfet_01v8_hvt ad=0.07665 pd=0.785 as=0.06825 ps=0.745 w=0.42 l=0.15
X890 halfP/RDA.R1_3 halfP/RDA.R2_4 VGND sky130_fd_pr__res_xhigh_po_0p35 l=30.3
X891 a_18348_43633# a_17949_43261# a_18222_43255# VGND sky130_fd_pr__special_nfet_01v8 ad=0.0696 pd=0.765 as=0.0621 ps=0.705 w=0.36 l=0.15
X892 VGND a_25246_43229# a_25204_43633# VGND sky130_fd_pr__nfet_01v8 ad=0.12095 pd=1.085 as=0.0696 ps=0.765 w=0.42 l=0.15
X893 VGND a_25671_39965# a_25629_40369# VGND sky130_fd_pr__nfet_01v8 ad=0.1092 pd=1.36 as=0.066 ps=0.745 w=0.42 l=0.15
X894 a_24805_42711# a_24639_42711# VGND VGND sky130_fd_pr__nfet_01v8 ad=0.1092 pd=1.36 as=0.0567 ps=0.69 w=0.42 l=0.15
X895 VGND clk a_15667_43261# VGND sky130_fd_pr__nfet_01v8 ad=0.0567 pd=0.69 as=0.1092 ps=1.36 w=0.42 l=0.15
X896 a_11127_42385# clk VDPWR VDPWR sky130_fd_pr__pfet_01v8_hvt ad=0.1664 pd=1.8 as=0.0864 ps=0.91 w=0.64 l=0.15
X897 uio_out[7] a_9767_43229# VDPWR VDPWR sky130_fd_pr__pfet_01v8_hvt ad=0.135 pd=1.27 as=0.135 ps=1.27 w=1 l=0.15
X898 a_26119_39991# halfP/xq6.B VGND VGND sky130_fd_pr__nfet_01v8 ad=0.08775 pd=0.92 as=0.169 ps=1.82 w=0.65 l=0.15
X899 VGND a_3811_40209# a_3818_40113# VGND sky130_fd_pr__nfet_01v8 ad=0.0567 pd=0.69 as=0.1092 ps=1.36 w=0.42 l=0.15
X900 VDPWR a_16274_43229# a_16201_43255# VDPWR sky130_fd_pr__pfet_01v8_hvt ad=0.17887 pd=1.26 as=0.07665 ps=0.785 w=0.42 l=0.15
X901 a_3746_42711# a_3431_42863# VGND VGND sky130_fd_pr__nfet_01v8 ad=0.066 pd=0.745 as=0.1092 ps=1.36 w=0.42 l=0.15
X902 VDPWR a_17746_41735# a_17673_41989# VDPWR sky130_fd_pr__pfet_01v8_hvt ad=0.17887 pd=1.26 as=0.07665 ps=0.785 w=0.42 l=0.15
X903 VGND a_4018_40268# a_3947_40369# VGND sky130_fd_pr__nfet_01v8 ad=0.12095 pd=1.085 as=0.0989 ps=0.995 w=0.64 l=0.15
X904 VGND a_16515_42979# a_16473_42711# VGND sky130_fd_pr__nfet_01v8 ad=0.1092 pd=1.36 as=0.066 ps=0.745 w=0.42 l=0.15
X905 a_2799_41053# halfN/xq4.B a_3185_41079# VDPWR sky130_fd_pr__pfet_01v8_hvt ad=0.26 pd=2.52 as=0.135 ps=1.27 w=1 l=0.15
X906 a_10667_43473# clk VGND VGND sky130_fd_pr__nfet_01v8 ad=0.1092 pd=1.36 as=0.0567 ps=0.69 w=0.42 l=0.15
X907 VDPWR a_12527_41597# uio_out[1] VDPWR sky130_fd_pr__pfet_01v8_hvt ad=0.135 pd=1.27 as=0.135 ps=1.27 w=1 l=0.15
X908 a_15373_42173# a_15207_42173# VDPWR VDPWR sky130_fd_pr__pfet_01v8_hvt ad=0.1664 pd=1.8 as=0.0864 ps=0.91 w=0.64 l=0.15
X909 halfN/RDA.R1_21 halfN/RDA.R2_22 VGND sky130_fd_pr__res_xhigh_po_0p35 l=30.3
X910 halfN/RDA.R1_35 halfN/RIN.R2_1 VGND sky130_fd_pr__res_xhigh_po_0p35 l=30.3
X911 a_12527_41597# halfN/xq0.A VDPWR VDPWR sky130_fd_pr__pfet_01v8_hvt ad=0.26 pd=2.52 as=0.135 ps=1.27 w=1 l=0.15
X912 a_25246_41053# a_25078_41079# VGND VGND sky130_fd_pr__nfet_01v8 ad=0.0989 pd=0.995 as=0.12095 ps=1.085 w=0.64 l=0.15
X913 halfN/RDA.R1_23 halfN/RDA.R2_22 VGND sky130_fd_pr__res_xhigh_po_0p35 l=30.3
X914 a_24993_39991# halfP/obuf5.A VDPWR VDPWR sky130_fd_pr__pfet_01v8_hvt ad=0.05775 pd=0.695 as=0.1092 ps=1.36 w=0.42 l=0.15
X915 a_3527_42685# a_3818_42985# a_3769_43077# VDPWR sky130_fd_pr__pfet_01v8_hvt ad=0.0567 pd=0.69 as=0.0882 ps=0.84 w=0.42 l=0.15
X916 VGND a_4018_42685# a_3947_42711# VGND sky130_fd_pr__nfet_01v8 ad=0.12095 pd=1.085 as=0.0989 ps=0.995 w=0.64 l=0.15
X917 a_3185_40785# halfN/obuf3.A VDPWR VDPWR sky130_fd_pr__pfet_01v8_hvt ad=0.135 pd=1.27 as=0.135 ps=1.27 w=1 l=0.15
X918 a_16197_42545# a_15207_42173# a_16071_42167# VGND sky130_fd_pr__special_nfet_01v8 ad=0.066 pd=0.745 as=0.0684 ps=0.74 w=0.36 l=0.15
X919 VGND RB.R2_1 a_24244_26120# VGND sky130_fd_pr__nfet_01v8 ad=0.1386 pd=1.5 as=0.1386 ps=1.5 w=0.42 l=8
X920 halfP/mon.A halfP/dff5.D a_16606_39596# VDPWR sky130_fd_pr__pfet_01v8 ad=0.33 pd=2.66 as=0.15 ps=1.3 w=1 l=0.15
X921 VDPWR halfN/dff5.D a_11221_43633# VDPWR sky130_fd_pr__pfet_01v8_hvt ad=0.1092 pd=1.36 as=0.05775 ps=0.695 w=0.42 l=0.15
X922 VDPWR a_17139_43255# uo_out[3] VDPWR sky130_fd_pr__pfet_01v8_hvt ad=0.26 pd=2.52 as=0.135 ps=1.27 w=1 l=0.15
X923 a_26369_41079# halfP/obuf6.A VDPWR VDPWR sky130_fd_pr__pfet_01v8_hvt ad=0.135 pd=1.27 as=0.135 ps=1.27 w=1 l=0.15
X924 halfP/RDA.R1_7 halfP/xq1.X VGND sky130_fd_pr__res_xhigh_po_0p35 l=30.3
X925 a_25503_43077# a_24639_42711# a_25246_42823# VDPWR sky130_fd_pr__pfet_01v8_hvt ad=0.0567 pd=0.69 as=0.1095 ps=1.075 w=0.42 l=0.15
X926 VGND a_25246_42823# a_25204_42711# VGND sky130_fd_pr__nfet_01v8 ad=0.12095 pd=1.085 as=0.0696 ps=0.765 w=0.42 l=0.15
X927 VGND a_16239_42141# a_16197_42545# VGND sky130_fd_pr__nfet_01v8 ad=0.1092 pd=1.36 as=0.066 ps=0.745 w=0.42 l=0.15
X928 a_25173_43077# a_24639_42711# a_25078_43077# VDPWR sky130_fd_pr__pfet_01v8_hvt ad=0.07665 pd=0.785 as=0.06825 ps=0.745 w=0.42 l=0.15
X929 a_4018_42444# a_3818_42289# a_4167_42533# VGND sky130_fd_pr__special_nfet_01v8 ad=0.0621 pd=0.705 as=0.0696 ps=0.765 w=0.36 l=0.15
X930 VGND a_18647_43255# a_18815_43229# VGND sky130_fd_pr__nfet_01v8 ad=0.08775 pd=0.92 as=0.169 ps=1.82 w=0.65 l=0.15
X931 VDPWR a_18647_43255# a_18815_43229# VDPWR sky130_fd_pr__pfet_01v8_hvt ad=0.135 pd=1.27 as=0.27 ps=2.54 w=1 l=0.15
X932 a_12294_39236# halfN/mon.A halfN/dff4.D VGND sky130_fd_pr__nfet_01v8 ad=0.075 pd=0.8 as=0.165 ps=1.66 w=0.5 l=0.15
X933 VDPWR halfP/obuf3.A a_26201_40785# VDPWR sky130_fd_pr__pfet_01v8_hvt ad=0.135 pd=1.27 as=0.135 ps=1.27 w=1 l=0.15
X934 a_3947_40369# a_3818_40113# a_3527_40223# VGND sky130_fd_pr__special_nfet_01v8 ad=0.0989 pd=0.995 as=0.0684 ps=0.74 w=0.36 l=0.15
X935 VGND a_14183_42685# uio_out[0] VGND sky130_fd_pr__nfet_01v8 ad=0.08775 pd=0.92 as=0.08775 ps=0.92 w=0.65 l=0.15
X936 halfP/xq1.X halfP/xq1.B a_26369_42711# VGND sky130_fd_pr__nfet_01v8 ad=0.25025 pd=1.42 as=0.08775 ps=0.92 w=0.65 l=0.15
X937 VDPWR halfN/obuf5.A a_2829_39991# VDPWR sky130_fd_pr__pfet_01v8_hvt ad=0.135 pd=1.27 as=0.135 ps=1.27 w=1 l=0.15
X938 VDPWR a_25246_42823# a_25173_43077# VDPWR sky130_fd_pr__pfet_01v8_hvt ad=0.17887 pd=1.26 as=0.07665 ps=0.785 w=0.42 l=0.15
X939 a_11667_41623# a_11447_41623# VGND VGND sky130_fd_pr__nfet_01v8 ad=0.0696 pd=0.765 as=0.12095 ps=1.085 w=0.42 l=0.15
X940 VGND a_17746_41735# a_17704_41623# VGND sky130_fd_pr__nfet_01v8 ad=0.12095 pd=1.085 as=0.0696 ps=0.765 w=0.42 l=0.15
X941 RARR.R1_3 RARR.R2_2 VGND sky130_fd_pr__res_xhigh_po_0p35 l=20
X942 VGND a_11127_42385# a_11134_42289# VGND sky130_fd_pr__nfet_01v8 ad=0.0567 pd=0.69 as=0.1092 ps=1.36 w=0.42 l=0.15
X943 a_3811_43473# clk VGND VGND sky130_fd_pr__nfet_01v8 ad=0.1092 pd=1.36 as=0.0567 ps=0.69 w=0.42 l=0.15
X944 a_11062_42533# a_10747_42399# VGND VGND sky130_fd_pr__nfet_01v8 ad=0.066 pd=0.745 as=0.1092 ps=1.36 w=0.42 l=0.15
X945 halfP/RDA.R1_33 halfP/RDA.R2_32 VGND sky130_fd_pr__res_xhigh_po_0p35 l=30.3
X946 halfP/RDA.R1_19 halfP/xq3.X VGND sky130_fd_pr__res_xhigh_po_0p35 l=30.3
X947 a_11883_43229# halfN/xq1.A VDPWR VDPWR sky130_fd_pr__pfet_01v8_hvt ad=0.26 pd=2.52 as=0.135 ps=1.27 w=1 l=0.15
X948 VGND a_19255_43255# uo_out[0] VGND sky130_fd_pr__nfet_01v8 ad=0.08775 pd=0.92 as=0.08775 ps=0.92 w=0.65 l=0.15
X949 a_3527_42399# a_3818_42289# a_3769_42167# VDPWR sky130_fd_pr__pfet_01v8_hvt ad=0.0567 pd=0.69 as=0.0882 ps=0.84 w=0.42 l=0.15
X950 VDPWR a_25503_42167# a_25671_42141# VDPWR sky130_fd_pr__pfet_01v8_hvt ad=0.135 pd=1.27 as=0.27 ps=2.54 w=1 l=0.15
X951 VGND a_25503_42167# a_25671_42141# VGND sky130_fd_pr__nfet_01v8 ad=0.08775 pd=0.92 as=0.169 ps=1.82 w=0.65 l=0.15
X952 a_24993_41079# halfP/obuf6.A VGND VGND sky130_fd_pr__nfet_01v8 ad=0.0813 pd=0.83 as=0.1092 ps=1.36 w=0.42 l=0.15
X953 halfP/RDA.R1_31 halfP/RDA.R2_32 VGND sky130_fd_pr__res_xhigh_po_0p35 l=30.3
X954 VDPWR a_19300_24748# halfP/CM1.C2 VDPWR sky130_fd_pr__pfet_01v8 ad=0.74 pd=4.37 as=0.74 ps=4.37 w=4 l=2
X955 a_26201_39991# halfP/xq6.B a_26119_39991# VDPWR sky130_fd_pr__pfet_01v8_hvt ad=0.135 pd=1.27 as=0.26 ps=2.52 w=1 l=0.15
X956 a_2829_42167# halfN/xq2.B VDPWR VDPWR sky130_fd_pr__pfet_01v8_hvt ad=0.135 pd=1.27 as=0.26 ps=2.52 w=1 l=0.15
X957 a_13981_41623# a_13427_41597# a_13634_41597# VGND sky130_fd_pr__special_nfet_01v8 ad=0.0813 pd=0.83 as=0.0621 ps=0.705 w=0.36 l=0.15
X958 halfP/xq6.X a_26119_39991# a_26369_39991# VDPWR sky130_fd_pr__pfet_01v8_hvt ad=0.3 pd=2.6 as=0.26 ps=2.52 w=1 l=0.15
X959 VDPWR a_3431_42399# halfN/xq2.B VDPWR sky130_fd_pr__pfet_01v8_hvt ad=0.135 pd=1.27 as=0.26 ps=2.52 w=1 l=0.15
X960 a_25503_42167# a_24639_42173# a_25246_42141# VDPWR sky130_fd_pr__pfet_01v8_hvt ad=0.0567 pd=0.69 as=0.1095 ps=1.075 w=0.42 l=0.15
X961 uio_out[1] a_12527_41597# VDPWR VDPWR sky130_fd_pr__pfet_01v8_hvt ad=0.135 pd=1.27 as=0.26 ps=2.52 w=1 l=0.15
X962 VDPWR halfP/xq2.A a_18611_41623# VDPWR sky130_fd_pr__pfet_01v8_hvt ad=0.135 pd=1.27 as=0.26 ps=2.52 w=1 l=0.15
X963 a_25173_42167# a_24639_42173# a_25078_42167# VDPWR sky130_fd_pr__pfet_01v8_hvt ad=0.07665 pd=0.785 as=0.06825 ps=0.745 w=0.42 l=0.15
X964 a_25078_40901# a_24805_40535# a_24993_40535# VDPWR sky130_fd_pr__pfet_01v8_hvt ad=0.06825 pd=0.745 as=0.05775 ps=0.695 w=0.42 l=0.15
X965 VGND a_12067_42685# uio_out[3] VGND sky130_fd_pr__nfet_01v8 ad=0.08775 pd=0.92 as=0.08775 ps=0.92 w=0.65 l=0.15
X966 VDPWR clk a_15207_42173# VDPWR sky130_fd_pr__pfet_01v8_hvt ad=0.0864 pd=0.91 as=0.1664 ps=1.8 w=0.64 l=0.15
X967 VDPWR clk a_24639_41085# VDPWR sky130_fd_pr__pfet_01v8_hvt ad=0.0864 pd=0.91 as=0.1664 ps=1.8 w=0.64 l=0.15
X968 a_12774_39236# halfN/dff5.D halfN/mon.A VGND sky130_fd_pr__nfet_01v8 ad=0.075 pd=0.8 as=0.165 ps=1.66 w=0.5 l=0.15
X969 VDPWR a_12527_41597# uio_out[1] VDPWR sky130_fd_pr__pfet_01v8_hvt ad=0.135 pd=1.27 as=0.135 ps=1.27 w=1 l=0.15
X970 halfP/xq0.A a_16055_41891# VDPWR VDPWR sky130_fd_pr__pfet_01v8_hvt ad=0.26 pd=2.52 as=0.135 ps=1.27 w=1 l=0.15
X971 a_13350_43077# a_13103_42711# VDPWR VDPWR sky130_fd_pr__pfet_01v8_hvt ad=0.07665 pd=0.785 as=0.17887 ps=1.26 w=0.42 l=0.15
X972 VGND a_11311_41597# a_11318_41897# VGND sky130_fd_pr__nfet_01v8 ad=0.0567 pd=0.69 as=0.1092 ps=1.36 w=0.42 l=0.15
X973 VGND a_9954_39096# a_9954_39096# VGND sky130_fd_pr__nfet_01v8 ad=0.165 pd=1.66 as=0.165 ps=1.66 w=0.5 l=1
X974 a_25078_40901# a_24639_40535# a_24993_40535# VGND sky130_fd_pr__special_nfet_01v8 ad=0.0621 pd=0.705 as=0.0813 ps=0.83 w=0.36 l=0.15
X975 halfN/xq1.X a_2799_42896# VGND VGND sky130_fd_pr__nfet_01v8 ad=0.25025 pd=1.42 as=0.208 ps=1.94 w=0.65 l=0.15
X976 VGND halfN/xq1.B a_2799_42896# VGND sky130_fd_pr__nfet_01v8 ad=0.169 pd=1.82 as=0.08775 ps=0.92 w=0.65 l=0.15
X977 uo_out[4] a_16955_42711# VGND VGND sky130_fd_pr__nfet_01v8 ad=0.08775 pd=0.92 as=0.08775 ps=0.92 w=0.65 l=0.15
X978 VDPWR a_25246_42141# a_25173_42167# VDPWR sky130_fd_pr__pfet_01v8_hvt ad=0.17887 pd=1.26 as=0.07665 ps=0.785 w=0.42 l=0.15
X979 VDPWR halfN/xq3.A a_4365_41623# VDPWR sky130_fd_pr__pfet_01v8_hvt ad=0.1092 pd=1.36 as=0.05775 ps=0.695 w=0.42 l=0.15
X980 a_12294_39596# halfN/mon.A halfN/dff4.D VDPWR sky130_fd_pr__pfet_01v8 ad=0.15 pd=1.3 as=0.33 ps=2.66 w=1 l=0.15
X981 a_18087_41989# a_17305_41623# a_18003_41989# VDPWR sky130_fd_pr__pfet_01v8_hvt ad=0.0882 pd=0.84 as=0.0567 ps=0.69 w=0.42 l=0.15
X982 a_3431_40687# a_3527_40509# VGND VGND sky130_fd_pr__nfet_01v8 ad=0.169 pd=1.82 as=0.08775 ps=0.92 w=0.65 l=0.15
X983 a_10625_43255# a_10287_43487# VDPWR VDPWR sky130_fd_pr__pfet_01v8_hvt ad=0.0882 pd=0.84 as=0.1113 ps=1.37 w=0.42 l=0.15
X984 a_13103_42711# a_12974_42985# a_12683_42685# VGND sky130_fd_pr__special_nfet_01v8 ad=0.0989 pd=0.995 as=0.0684 ps=0.74 w=0.36 l=0.15
X985 a_15462_41989# a_15023_41623# a_15377_41623# VGND sky130_fd_pr__special_nfet_01v8 ad=0.0621 pd=0.705 as=0.0813 ps=0.83 w=0.36 l=0.15
X986 halfP/RDA.R1_35 halfP/RIN.R2_1 VGND sky130_fd_pr__res_xhigh_po_0p35 l=30.3
X987 VGND halfP/xq1.A a_17139_43255# VGND sky130_fd_pr__nfet_01v8 ad=0.08775 pd=0.92 as=0.169 ps=1.82 w=0.65 l=0.15
X988 a_3811_42685# clk VGND VGND sky130_fd_pr__nfet_01v8 ad=0.1092 pd=1.36 as=0.0567 ps=0.69 w=0.42 l=0.15
X989 a_13174_42685# a_12967_42685# a_13350_43077# VDPWR sky130_fd_pr__pfet_01v8_hvt ad=0.06825 pd=0.745 as=0.07665 ps=0.785 w=0.42 l=0.15
X990 a_5356_24748# halfN/RIN.R2_1 halfN/CM1.C2 VGND sky130_fd_pr__nfet_01v8 ad=2.22 pd=12.37 as=2.22 ps=12.37 w=12 l=3
X991 halfP/RDA.R1_35 halfP/RDA.R2_34 VGND sky130_fd_pr__res_xhigh_po_0p35 l=30.3
X992 a_24993_40535# halfP/obuf3.A VGND VGND sky130_fd_pr__nfet_01v8 ad=0.0813 pd=0.83 as=0.1092 ps=1.36 w=0.42 l=0.15
X993 a_4194_43077# a_3947_42711# VDPWR VDPWR sky130_fd_pr__pfet_01v8_hvt ad=0.07665 pd=0.785 as=0.17887 ps=1.26 w=0.42 l=0.15
X994 a_26369_42711# halfP/xq1.A VGND VGND sky130_fd_pr__nfet_01v8 ad=0.08775 pd=0.92 as=0.08775 ps=0.92 w=0.65 l=0.15
X995 a_3185_42167# halfN/xq2.A VDPWR VDPWR sky130_fd_pr__pfet_01v8_hvt ad=0.135 pd=1.27 as=0.135 ps=1.27 w=1 l=0.15
X996 a_25246_41735# a_25078_41989# VDPWR VDPWR sky130_fd_pr__pfet_01v8_hvt ad=0.1095 pd=1.075 as=0.17887 ps=1.26 w=0.75 l=0.15
X997 VDPWR a_10411_41597# uio_out[5] VDPWR sky130_fd_pr__pfet_01v8_hvt ad=0.135 pd=1.27 as=0.135 ps=1.27 w=1 l=0.15
X998 a_17762_42167# a_17323_42173# a_17677_42167# VGND sky130_fd_pr__special_nfet_01v8 ad=0.0621 pd=0.705 as=0.0813 ps=0.83 w=0.36 l=0.15
X999 a_19300_24748# RBT.R2_0 a_17026_24748# VGND sky130_fd_pr__nfet_01v8 ad=2.22 pd=12.37 as=2.22 ps=12.37 w=12 l=3
X1000 RB.R1_0 VDPWR VGND sky130_fd_pr__res_xhigh_po_0p35 l=3.65
X1001 a_19300_24748# a_19300_24748# VDPWR VDPWR sky130_fd_pr__pfet_01v8 ad=0.74 pd=4.37 as=1.32 ps=8.66 w=4 l=2
X1002 a_18731_43255# a_17949_43261# a_18647_43255# VDPWR sky130_fd_pr__pfet_01v8_hvt ad=0.0882 pd=0.84 as=0.0567 ps=0.69 w=0.42 l=0.15
X1003 a_16431_43077# a_15649_42711# a_16347_43077# VDPWR sky130_fd_pr__pfet_01v8_hvt ad=0.0882 pd=0.84 as=0.0567 ps=0.69 w=0.42 l=0.15
X1004 a_4018_42685# a_3811_42685# a_4194_43077# VDPWR sky130_fd_pr__pfet_01v8_hvt ad=0.06825 pd=0.745 as=0.07665 ps=0.785 w=0.42 l=0.15
X1005 VDPWR halfN/xq3.A a_2829_41873# VDPWR sky130_fd_pr__pfet_01v8_hvt ad=0.135 pd=1.27 as=0.135 ps=1.27 w=1 l=0.15
X1006 a_25503_41989# a_24805_41623# a_25246_41735# VGND sky130_fd_pr__special_nfet_01v8 ad=0.0684 pd=0.74 as=0.0989 ps=0.995 w=0.36 l=0.15
X1007 a_10843_42399# a_11127_42385# a_11062_42533# VGND sky130_fd_pr__special_nfet_01v8 ad=0.0684 pd=0.74 as=0.066 ps=0.745 w=0.36 l=0.15
X1008 VGND RB.R2_1 a_5356_24748# VGND sky130_fd_pr__nfet_01v8 ad=0.37 pd=2.37 as=0.37 ps=2.37 w=2 l=2
X1009 a_12774_39596# halfN/dff5.D halfN/mon.A VDPWR sky130_fd_pr__pfet_01v8 ad=0.15 pd=1.3 as=0.33 ps=2.66 w=1 l=0.15
X1010 VDPWR halfP/xq2.A a_26201_42167# VDPWR sky130_fd_pr__pfet_01v8_hvt ad=0.135 pd=1.27 as=0.135 ps=1.27 w=1 l=0.15
X1011 VDPWR a_25671_41891# a_25587_41989# VDPWR sky130_fd_pr__pfet_01v8_hvt ad=0.1113 pd=1.37 as=0.0882 ps=0.84 w=0.42 l=0.15
X1012 a_24805_39997# a_24639_39997# VGND VGND sky130_fd_pr__nfet_01v8 ad=0.1092 pd=1.36 as=0.0567 ps=0.69 w=0.42 l=0.15
X1013 VGND halfN/obuf3.A a_3017_40535# VGND sky130_fd_pr__nfet_01v8 ad=0.08775 pd=0.92 as=0.08775 ps=0.92 w=0.65 l=0.15
X1014 a_15377_41623# halfP/mon.A VDPWR VDPWR sky130_fd_pr__pfet_01v8_hvt ad=0.05775 pd=0.695 as=0.1092 ps=1.36 w=0.42 l=0.15
X1015 VDPWR a_9954_39570# a_9954_39096# VDPWR sky130_fd_pr__pfet_01v8 ad=0.33 pd=2.66 as=0.33 ps=2.66 w=1 l=1
X1016 VGND a_17930_42141# a_17888_42545# VGND sky130_fd_pr__nfet_01v8 ad=0.12095 pd=1.085 as=0.0696 ps=0.765 w=0.42 l=0.15
X1017 a_2829_41079# a_2799_41053# halfN/xq4.X VDPWR sky130_fd_pr__pfet_01v8_hvt ad=0.26 pd=2.52 as=0.3 ps=2.6 w=1 l=0.15
X1018 a_11814_39236# halfN/dff4.D halfN/dff1.D VGND sky130_fd_pr__nfet_01v8 ad=0.075 pd=0.8 as=0.165 ps=1.66 w=0.5 l=0.15
X1019 VDPWR a_10227_42141# uio_out[6] VDPWR sky130_fd_pr__pfet_01v8_hvt ad=0.135 pd=1.27 as=0.135 ps=1.27 w=1 l=0.15
X1020 a_3769_43255# a_3431_43487# VDPWR VDPWR sky130_fd_pr__pfet_01v8_hvt ad=0.0882 pd=0.84 as=0.1113 ps=1.37 w=0.42 l=0.15
X1021 uio_out[3] a_12067_42685# VGND VGND sky130_fd_pr__nfet_01v8 ad=0.08775 pd=0.92 as=0.169 ps=1.82 w=0.65 l=0.15
X1022 VDPWR halfN/mon.A a_13981_41623# VDPWR sky130_fd_pr__pfet_01v8_hvt ad=0.1092 pd=1.36 as=0.05775 ps=0.695 w=0.42 l=0.15
X1023 a_3746_40357# a_3431_40223# VGND VGND sky130_fd_pr__nfet_01v8 ad=0.066 pd=0.745 as=0.1092 ps=1.36 w=0.42 l=0.15
X1024 a_12067_42685# halfN/obuf6.A VDPWR VDPWR sky130_fd_pr__pfet_01v8_hvt ad=0.26 pd=2.52 as=0.135 ps=1.27 w=1 l=0.15
X1025 a_26201_41873# halfP/xq3.B a_26119_41873# VDPWR sky130_fd_pr__pfet_01v8_hvt ad=0.135 pd=1.27 as=0.26 ps=2.52 w=1 l=0.15
X1026 VDPWR halfP/mon.A a_14839_42711# VDPWR sky130_fd_pr__pfet_01v8_hvt ad=0.135 pd=1.27 as=0.26 ps=2.52 w=1 l=0.15
X1027 a_15649_42711# a_15483_42711# VGND VGND sky130_fd_pr__nfet_01v8 ad=0.1092 pd=1.36 as=0.0567 ps=0.69 w=0.42 l=0.15
X1028 a_10227_42141# halfN/obuf3.A VDPWR VDPWR sky130_fd_pr__pfet_01v8_hvt ad=0.26 pd=2.52 as=0.135 ps=1.27 w=1 l=0.15
X1029 VDPWR a_6022_24748# a_6022_24748# VDPWR sky130_fd_pr__pfet_01v8 ad=0.74 pd=4.37 as=0.74 ps=4.37 w=4 l=2
X1030 a_4194_42167# a_3947_42545# VDPWR VDPWR sky130_fd_pr__pfet_01v8_hvt ad=0.07665 pd=0.785 as=0.17887 ps=1.26 w=0.42 l=0.15
X1031 VGND clk a_15023_41623# VGND sky130_fd_pr__nfet_01v8 ad=0.0567 pd=0.69 as=0.1092 ps=1.36 w=0.42 l=0.15
X1032 halfP/xq3.X a_26119_41873# a_26369_41873# VDPWR sky130_fd_pr__pfet_01v8_hvt ad=0.3 pd=2.6 as=0.26 ps=2.52 w=1 l=0.15
X1033 VDPWR a_16955_42711# uo_out[4] VDPWR sky130_fd_pr__pfet_01v8_hvt ad=0.26 pd=2.52 as=0.135 ps=1.27 w=1 l=0.15
X1034 halfN/RDA.R1_1 halfN/xq0.X VGND sky130_fd_pr__res_xhigh_po_0p35 l=30.3
X1035 a_25078_39991# a_24639_39997# a_24993_39991# VGND sky130_fd_pr__special_nfet_01v8 ad=0.0621 pd=0.705 as=0.0813 ps=0.83 w=0.36 l=0.15
X1036 a_26119_40785# halfP/xq5.B VGND VGND sky130_fd_pr__nfet_01v8 ad=0.08775 pd=0.92 as=0.169 ps=1.82 w=0.65 l=0.15
X1037 a_11127_42385# clk VGND VGND sky130_fd_pr__nfet_01v8 ad=0.1092 pd=1.36 as=0.0567 ps=0.69 w=0.42 l=0.15
X1038 RBT.R1_0 RBT.R2_0 VGND sky130_fd_pr__res_xhigh_po_0p35 l=4.38
X1039 RB.R2_1 RB.R2_1 VGND VGND sky130_fd_pr__nfet_01v8 ad=0.37 pd=2.37 as=0.66 ps=4.66 w=2 l=2
X1040 VDPWR halfP/xq3.A a_16679_42167# VDPWR sky130_fd_pr__pfet_01v8_hvt ad=0.135 pd=1.27 as=0.26 ps=2.52 w=1 l=0.15
X1041 halfP/xq0.X halfP/xq0.B a_26369_43575# VGND sky130_fd_pr__nfet_01v8 ad=0.25025 pd=1.42 as=0.08775 ps=0.92 w=0.65 l=0.15
X1042 a_4018_42444# a_3811_42385# a_4194_42167# VDPWR sky130_fd_pr__pfet_01v8_hvt ad=0.06825 pd=0.745 as=0.07665 ps=0.785 w=0.42 l=0.15
X1043 a_12683_42685# a_12974_42985# a_12925_43077# VDPWR sky130_fd_pr__pfet_01v8_hvt ad=0.0567 pd=0.69 as=0.0882 ps=0.84 w=0.42 l=0.15
X1044 uo_out[5] a_16679_42167# VDPWR VDPWR sky130_fd_pr__pfet_01v8_hvt ad=0.135 pd=1.27 as=0.135 ps=1.27 w=1 l=0.15
X1045 VGND a_18003_41989# a_18171_41891# VGND sky130_fd_pr__nfet_01v8 ad=0.08775 pd=0.92 as=0.169 ps=1.82 w=0.65 l=0.15
X1046 a_4167_41445# a_3947_41457# VGND VGND sky130_fd_pr__nfet_01v8 ad=0.0696 pd=0.765 as=0.12095 ps=1.085 w=0.42 l=0.15
X1047 a_5356_24748# RB.R2_1 VGND VGND sky130_fd_pr__nfet_01v8 ad=0.37 pd=2.37 as=0.66 ps=4.66 w=2 l=2
X1048 VGND a_25246_39965# a_25204_40369# VGND sky130_fd_pr__nfet_01v8 ad=0.12095 pd=1.085 as=0.0696 ps=0.765 w=0.42 l=0.15
X1049 tie_oe2.LO VGND sky130_fd_pr__res_generic_po w=0.48 l=0.5
X1050 a_15373_42173# a_15207_42173# VGND VGND sky130_fd_pr__nfet_01v8 ad=0.1092 pd=1.36 as=0.0567 ps=0.69 w=0.42 l=0.15
X1051 VDPWR a_9954_39570# a_9954_39570# VDPWR sky130_fd_pr__pfet_01v8 ad=0.33 pd=2.66 as=0.33 ps=2.66 w=1 l=1
X1052 VGND a_26119_42961# halfP/xq1.X VGND sky130_fd_pr__nfet_01v8 ad=0.208 pd=1.94 as=0.25025 ps=1.42 w=0.65 l=0.15
X1053 a_3017_40311# halfN/xq6.B halfN/xq6.X VGND sky130_fd_pr__nfet_01v8 ad=0.08775 pd=0.92 as=0.25025 ps=1.42 w=0.65 l=0.15
X1054 VDPWR a_10874_43532# a_10803_43633# VDPWR sky130_fd_pr__pfet_01v8_hvt ad=0.17887 pd=1.26 as=0.1095 ps=1.075 w=0.75 l=0.15
X1055 a_3527_41597# a_3811_41597# a_3746_41623# VGND sky130_fd_pr__special_nfet_01v8 ad=0.0684 pd=0.74 as=0.066 ps=0.745 w=0.36 l=0.15
X1056 VDPWR a_3811_41297# a_3818_41201# VDPWR sky130_fd_pr__pfet_01v8_hvt ad=0.0864 pd=0.91 as=0.1664 ps=1.8 w=0.64 l=0.15
X1057 a_18647_43255# a_17783_43261# a_18390_43229# VDPWR sky130_fd_pr__pfet_01v8_hvt ad=0.0567 pd=0.69 as=0.1095 ps=1.075 w=0.42 l=0.15
X1058 a_16347_43077# a_15483_42711# a_16090_42823# VDPWR sky130_fd_pr__pfet_01v8_hvt ad=0.0567 pd=0.69 as=0.1095 ps=1.075 w=0.42 l=0.15
X1059 VGND a_16090_42823# a_16048_42711# VGND sky130_fd_pr__nfet_01v8 ad=0.12095 pd=1.085 as=0.0696 ps=0.765 w=0.42 l=0.15
X1060 halfP/xq3.B a_25671_41891# VGND VGND sky130_fd_pr__nfet_01v8 ad=0.169 pd=1.82 as=0.08775 ps=0.92 w=0.65 l=0.15
X1061 a_24993_43255# halfP/xq0.A VDPWR VDPWR sky130_fd_pr__pfet_01v8_hvt ad=0.05775 pd=0.695 as=0.1092 ps=1.36 w=0.42 l=0.15
X1062 VDPWR a_6022_24748# a_6022_24748# VDPWR sky130_fd_pr__pfet_01v8 ad=1.32 pd=8.66 as=0.74 ps=4.37 w=4 l=2
X1063 halfN/RDA.R1_19 halfN/xq3.X VGND sky130_fd_pr__res_xhigh_po_0p35 l=30.3
X1064 halfN/RDA.R1_33 halfN/RDA.R2_32 VGND sky130_fd_pr__res_xhigh_po_0p35 l=30.3
X1065 a_11814_39596# halfN/dff4.D halfN/dff1.D VDPWR sky130_fd_pr__pfet_01v8 ad=0.15 pd=1.3 as=0.33 ps=2.66 w=1 l=0.15
X1066 a_11027_41597# a_11318_41897# a_11269_41989# VDPWR sky130_fd_pr__pfet_01v8_hvt ad=0.0567 pd=0.69 as=0.0882 ps=0.84 w=0.42 l=0.15
X1067 VDPWR halfN/obuf6.A a_4365_41457# VDPWR sky130_fd_pr__pfet_01v8_hvt ad=0.1092 pd=1.36 as=0.05775 ps=0.695 w=0.42 l=0.15
X1068 a_25503_41079# a_24805_41085# a_25246_41053# VGND sky130_fd_pr__special_nfet_01v8 ad=0.0684 pd=0.74 as=0.0989 ps=0.995 w=0.36 l=0.15
X1069 a_18222_43255# a_17949_43261# a_18137_43255# VDPWR sky130_fd_pr__pfet_01v8_hvt ad=0.06825 pd=0.745 as=0.05775 ps=0.695 w=0.42 l=0.15
X1070 VGND a_3431_41775# halfN/xq3.B VGND sky130_fd_pr__nfet_01v8 ad=0.08775 pd=0.92 as=0.169 ps=1.82 w=0.65 l=0.15
X1071 uio_out[1] a_12527_41597# VGND VGND sky130_fd_pr__nfet_01v8 ad=0.08775 pd=0.92 as=0.08775 ps=0.92 w=0.65 l=0.15
X1072 RBT.R1_2 RBT.R2_3 VGND sky130_fd_pr__res_xhigh_po_0p35 l=4.38
X1073 halfN/RDA.R1_19 halfN/RDA.R2_20 VGND sky130_fd_pr__res_xhigh_po_0p35 l=30.3
X1074 a_17677_42167# halfP/dff3.D VDPWR VDPWR sky130_fd_pr__pfet_01v8_hvt ad=0.05775 pd=0.695 as=0.1092 ps=1.36 w=0.42 l=0.15
X1075 halfP/RDA.R1_9 halfP/RDA.R2_10 VGND sky130_fd_pr__res_xhigh_po_0p35 l=30.3
X1076 VGND tie_oe7.LO sky130_fd_pr__res_generic_po w=0.48 l=0.5
X1077 a_16232_43633# a_15833_43261# a_16106_43255# VGND sky130_fd_pr__special_nfet_01v8 ad=0.0696 pd=0.765 as=0.0621 ps=0.705 w=0.36 l=0.15
X1078 uio_out[6] a_10227_42141# VDPWR VDPWR sky130_fd_pr__pfet_01v8_hvt ad=0.135 pd=1.27 as=0.26 ps=2.52 w=1 l=0.15
X1079 halfN/CM1.C2 irst.Y halfN/RIN.R2_1 VGND sky130_fd_pr__nfet_01v8 ad=0.1386 pd=1.5 as=0.1386 ps=1.5 w=0.42 l=0.15
X1080 VGND halfN/xq0.B a_2799_43229# VGND sky130_fd_pr__nfet_01v8 ad=0.169 pd=1.82 as=0.08775 ps=0.92 w=0.65 l=0.15
X1081 a_5356_24748# halfN/RIN.R2_1 halfN/CM1.C2 VGND sky130_fd_pr__nfet_01v8 ad=2.22 pd=12.37 as=2.22 ps=12.37 w=12 l=3
X1082 halfN/xq0.X a_2799_43229# VGND VGND sky130_fd_pr__nfet_01v8 ad=0.25025 pd=1.42 as=0.208 ps=1.94 w=0.65 l=0.15
X1083 VDPWR a_12067_42685# uio_out[3] VDPWR sky130_fd_pr__pfet_01v8_hvt ad=0.135 pd=1.27 as=0.135 ps=1.27 w=1 l=0.15
X1084 a_4365_41623# a_3818_41897# a_4018_41597# VDPWR sky130_fd_pr__pfet_01v8_hvt ad=0.05775 pd=0.695 as=0.06825 ps=0.745 w=0.42 l=0.15
X1085 a_3431_41311# a_3527_41311# VGND VGND sky130_fd_pr__nfet_01v8 ad=0.169 pd=1.82 as=0.08775 ps=0.92 w=0.65 l=0.15
X1086 a_4167_40535# a_3947_40535# VGND VGND sky130_fd_pr__nfet_01v8 ad=0.0696 pd=0.765 as=0.12095 ps=1.085 w=0.42 l=0.15
X1087 VDPWR halfP/obuf6.A a_16955_42711# VDPWR sky130_fd_pr__pfet_01v8_hvt ad=0.135 pd=1.27 as=0.26 ps=2.52 w=1 l=0.15
X1088 VDPWR a_10227_42141# uio_out[6] VDPWR sky130_fd_pr__pfet_01v8_hvt ad=0.135 pd=1.27 as=0.135 ps=1.27 w=1 l=0.15
X1089 VDPWR halfN/xq0.A a_2829_43255# VDPWR sky130_fd_pr__pfet_01v8_hvt ad=0.135 pd=1.27 as=0.135 ps=1.27 w=1 l=0.15
X1090 halfP/xq1.A a_16699_43229# VDPWR VDPWR sky130_fd_pr__pfet_01v8_hvt ad=0.26 pd=2.52 as=0.135 ps=1.27 w=1 l=0.15
X1091 VDPWR a_15630_41735# a_15557_41989# VDPWR sky130_fd_pr__pfet_01v8_hvt ad=0.17887 pd=1.26 as=0.07665 ps=0.785 w=0.42 l=0.15
X1092 halfP/xq5.B a_25671_40803# VDPWR VDPWR sky130_fd_pr__pfet_01v8_hvt ad=0.26 pd=2.52 as=0.135 ps=1.27 w=1 l=0.15
X1093 halfP/xq1.A a_16699_43229# VGND VGND sky130_fd_pr__nfet_01v8 ad=0.169 pd=1.82 as=0.08775 ps=0.92 w=0.65 l=0.15
X1094 uo_out[4] a_16955_42711# VDPWR VDPWR sky130_fd_pr__pfet_01v8_hvt ad=0.135 pd=1.27 as=0.135 ps=1.27 w=1 l=0.15
X1095 VDPWR clk a_24639_41623# VDPWR sky130_fd_pr__pfet_01v8_hvt ad=0.0864 pd=0.91 as=0.1664 ps=1.8 w=0.64 l=0.15
X1096 a_2799_39965# halfN/obuf5.A VGND VGND sky130_fd_pr__nfet_01v8 ad=0.08775 pd=0.92 as=0.08775 ps=0.92 w=0.65 l=0.15
X1097 VDPWR halfP/xq5.B a_26369_40785# VDPWR sky130_fd_pr__pfet_01v8_hvt ad=0.26 pd=2.52 as=0.135 ps=1.27 w=1 l=0.15
X1098 a_18526_39236# a_15786_39096# VGND VGND sky130_fd_pr__nfet_01v8 ad=0.075 pd=0.8 as=0.165 ps=1.66 w=0.5 l=1
X1099 a_25246_40647# a_25078_40901# VGND VGND sky130_fd_pr__nfet_01v8 ad=0.0989 pd=0.995 as=0.12095 ps=1.085 w=0.64 l=0.15
X1100 a_25204_43633# a_24805_43261# a_25078_43255# VGND sky130_fd_pr__special_nfet_01v8 ad=0.0696 pd=0.765 as=0.0621 ps=0.705 w=0.36 l=0.15
X1101 a_4365_42711# a_3811_42685# a_4018_42685# VGND sky130_fd_pr__special_nfet_01v8 ad=0.0813 pd=0.83 as=0.0621 ps=0.705 w=0.36 l=0.15
X1102 a_16615_43255# a_15833_43261# a_16531_43255# VDPWR sky130_fd_pr__pfet_01v8_hvt ad=0.0882 pd=0.84 as=0.0567 ps=0.69 w=0.42 l=0.15
X1103 a_15630_41735# a_15462_41989# VGND VGND sky130_fd_pr__nfet_01v8 ad=0.0989 pd=0.995 as=0.12095 ps=1.085 w=0.64 l=0.15
X1104 a_3431_40687# a_3527_40509# VDPWR VDPWR sky130_fd_pr__pfet_01v8_hvt ad=0.27 pd=2.54 as=0.135 ps=1.27 w=1 l=0.15
X1105 RT.R1_2 RT.R2_1 VGND sky130_fd_pr__res_xhigh_po_0p35 l=4.38
X1106 halfN/RDA.R1_15 halfN/RDA.R2_16 VGND sky130_fd_pr__res_xhigh_po_0p35 l=30.3
X1107 halfN/RDA.R1_29 halfN/RIN.R2_1 VGND sky130_fd_pr__res_xhigh_po_0p35 l=30.3
X1108 VGND a_9954_39096# a_12294_39236# VGND sky130_fd_pr__nfet_01v8 ad=0.165 pd=1.66 as=0.075 ps=0.8 w=0.5 l=1
X1109 a_26369_43575# halfP/xq0.A VGND VGND sky130_fd_pr__nfet_01v8 ad=0.08775 pd=0.92 as=0.08775 ps=0.92 w=0.65 l=0.15
X1110 VGND halfN/xq0.A a_4365_43633# VGND sky130_fd_pr__nfet_01v8 ad=0.1092 pd=1.36 as=0.0813 ps=0.83 w=0.42 l=0.15
X1111 VDPWR a_16679_42167# uo_out[5] VDPWR sky130_fd_pr__pfet_01v8_hvt ad=0.135 pd=1.27 as=0.135 ps=1.27 w=1 l=0.15
X1112 a_11246_41623# a_10931_41775# VGND VGND sky130_fd_pr__nfet_01v8 ad=0.066 pd=0.745 as=0.1092 ps=1.36 w=0.42 l=0.15
X1113 a_26201_43255# halfP/xq0.B a_26119_43255# VDPWR sky130_fd_pr__pfet_01v8_hvt ad=0.135 pd=1.27 as=0.26 ps=2.52 w=1 l=0.15
X1114 RT.R1_0 RT.R2_1 VGND sky130_fd_pr__res_xhigh_po_0p35 l=4.38
X1115 halfP/RDA.R1_21 halfP/RDA.R2_22 VGND sky130_fd_pr__res_xhigh_po_0p35 l=30.3
X1116 VDPWR a_16239_42141# a_16155_42167# VDPWR sky130_fd_pr__pfet_01v8_hvt ad=0.1113 pd=1.37 as=0.0882 ps=0.84 w=0.42 l=0.15
X1117 VDPWR a_25671_41053# a_25587_41079# VDPWR sky130_fd_pr__pfet_01v8_hvt ad=0.1113 pd=1.37 as=0.0882 ps=0.84 w=0.42 l=0.15
X1118 VDPWR clk a_24639_40535# VDPWR sky130_fd_pr__pfet_01v8_hvt ad=0.0864 pd=0.91 as=0.1664 ps=1.8 w=0.64 l=0.15
X1119 VGND tie_oe1.LO sky130_fd_pr__res_generic_po w=0.48 l=0.5
X1120 halfP/xq0.X a_26119_43255# a_26369_43255# VDPWR sky130_fd_pr__pfet_01v8_hvt ad=0.3 pd=2.6 as=0.26 ps=2.52 w=1 l=0.15
X1121 VGND clk a_15207_42173# VGND sky130_fd_pr__nfet_01v8 ad=0.0567 pd=0.69 as=0.1092 ps=1.36 w=0.42 l=0.15
X1122 VGND clk a_24639_41085# VGND sky130_fd_pr__nfet_01v8 ad=0.0567 pd=0.69 as=0.1092 ps=1.36 w=0.42 l=0.15
X1123 VDPWR clk a_24639_39997# VDPWR sky130_fd_pr__pfet_01v8_hvt ad=0.0864 pd=0.91 as=0.1664 ps=1.8 w=0.64 l=0.15
X1124 VGND a_19255_43255# uo_out[0] VGND sky130_fd_pr__nfet_01v8 ad=0.169 pd=1.82 as=0.08775 ps=0.92 w=0.65 l=0.15
X1125 a_11085_42167# a_10747_42399# VDPWR VDPWR sky130_fd_pr__pfet_01v8_hvt ad=0.0882 pd=0.84 as=0.1113 ps=1.37 w=0.42 l=0.15
X1126 a_5130_26120# RB.R2_1 VGND VGND sky130_fd_pr__nfet_01v8 ad=0.1386 pd=1.5 as=0.1386 ps=1.5 w=0.42 l=8
X1127 VGND RB.R2_1 a_17026_24748# VGND sky130_fd_pr__nfet_01v8 ad=0.66 pd=4.66 as=0.37 ps=2.37 w=2 l=2
X1128 VDPWR a_25503_39991# a_25671_39965# VDPWR sky130_fd_pr__pfet_01v8_hvt ad=0.135 pd=1.27 as=0.27 ps=2.54 w=1 l=0.15
X1129 VGND halfP/obuf5.A a_26119_39991# VGND sky130_fd_pr__nfet_01v8 ad=0.08775 pd=0.92 as=0.08775 ps=0.92 w=0.65 l=0.15
X1130 a_3811_40209# clk VGND VGND sky130_fd_pr__nfet_01v8 ad=0.1092 pd=1.36 as=0.0567 ps=0.69 w=0.42 l=0.15
X1131 a_3527_40223# a_3818_40113# a_3769_39991# VDPWR sky130_fd_pr__pfet_01v8_hvt ad=0.0567 pd=0.69 as=0.0882 ps=0.84 w=0.42 l=0.15
X1132 a_17026_24748# halfP/RIN.R2_1 halfP/CM1.C2 VGND sky130_fd_pr__nfet_01v8 ad=2.22 pd=12.37 as=2.22 ps=12.37 w=12 l=3
X1133 VGND halfN/dff4.D VGND VGND sky130_fd_pr__nfet_01v8 ad=0.49 pd=3.5 as=0 ps=0 w=1.4 l=2.86
X1134 VGND a_16055_41891# a_16013_41623# VGND sky130_fd_pr__nfet_01v8 ad=0.1092 pd=1.36 as=0.066 ps=0.745 w=0.42 l=0.15
X1135 a_2829_39991# halfN/xq6.B VDPWR VDPWR sky130_fd_pr__pfet_01v8_hvt ad=0.135 pd=1.27 as=0.26 ps=2.52 w=1 l=0.15
X1136 VDPWR a_13174_42685# a_13103_42711# VDPWR sky130_fd_pr__pfet_01v8_hvt ad=0.17887 pd=1.26 as=0.1095 ps=1.075 w=0.75 l=0.15
X1137 VGND halfN/dff6.D a_13521_42711# VGND sky130_fd_pr__nfet_01v8 ad=0.1092 pd=1.36 as=0.0813 ps=0.83 w=0.42 l=0.15
X1138 a_3527_41311# a_3811_41297# a_3746_41445# VGND sky130_fd_pr__special_nfet_01v8 ad=0.0684 pd=0.74 as=0.066 ps=0.745 w=0.36 l=0.15
X1139 a_25503_39991# a_24639_39997# a_25246_39965# VDPWR sky130_fd_pr__pfet_01v8_hvt ad=0.0567 pd=0.69 as=0.1095 ps=1.075 w=0.42 l=0.15
X1140 VDPWR a_18611_41623# uo_out[2] VDPWR sky130_fd_pr__pfet_01v8_hvt ad=0.135 pd=1.27 as=0.135 ps=1.27 w=1 l=0.15
X1141 VGND halfN/obuf6.A a_3017_41399# VGND sky130_fd_pr__nfet_01v8 ad=0.08775 pd=0.92 as=0.08775 ps=0.92 w=0.65 l=0.15
X1142 a_25173_39991# a_24639_39997# a_25078_39991# VDPWR sky130_fd_pr__pfet_01v8_hvt ad=0.07665 pd=0.785 as=0.06825 ps=0.745 w=0.42 l=0.15
X1143 VDPWR a_3431_40223# halfN/xq6.B VDPWR sky130_fd_pr__pfet_01v8_hvt ad=0.135 pd=1.27 as=0.26 ps=2.52 w=1 l=0.15
X1144 VGND halfN/dff2.D a_13797_42545# VGND sky130_fd_pr__nfet_01v8 ad=0.1092 pd=1.36 as=0.0813 ps=0.83 w=0.42 l=0.15
X1145 a_6022_24748# RBT.R2_0 a_5356_24748# VGND sky130_fd_pr__nfet_01v8 ad=2.22 pd=12.37 as=3.96 ps=24.66 w=12 l=3
X1146 a_19006_39236# a_15786_39096# VGND VGND sky130_fd_pr__nfet_01v8 ad=0.075 pd=0.8 as=0.165 ps=1.66 w=0.5 l=1
X1147 a_2799_40720# halfN/xq5.B a_3185_40785# VDPWR sky130_fd_pr__pfet_01v8_hvt ad=0.26 pd=2.52 as=0.135 ps=1.27 w=1 l=0.15
X1148 a_3947_42711# a_3811_42685# a_3527_42685# VDPWR sky130_fd_pr__pfet_01v8_hvt ad=0.1095 pd=1.075 as=0.0567 ps=0.69 w=0.42 l=0.15
X1149 a_25629_41623# a_24639_41623# a_25503_41989# VGND sky130_fd_pr__special_nfet_01v8 ad=0.066 pd=0.745 as=0.0684 ps=0.74 w=0.36 l=0.15
X1150 RT.R1_4 RT.R2_5 VGND sky130_fd_pr__res_xhigh_po_0p35 l=4.38
X1151 VGND a_9954_39096# a_12774_39236# VGND sky130_fd_pr__nfet_01v8 ad=0.165 pd=1.66 as=0.075 ps=0.8 w=0.5 l=1
X1152 VDPWR a_25246_39965# a_25173_39991# VDPWR sky130_fd_pr__pfet_01v8_hvt ad=0.17887 pd=1.26 as=0.07665 ps=0.785 w=0.42 l=0.15
X1153 VDPWR a_16679_42167# uo_out[5] VDPWR sky130_fd_pr__pfet_01v8_hvt ad=0.26 pd=2.52 as=0.135 ps=1.27 w=1 l=0.15
X1154 a_18526_39596# a_15306_39570# VDPWR VDPWR sky130_fd_pr__pfet_01v8 ad=0.15 pd=1.3 as=0.33 ps=2.66 w=1 l=1
X1155 uio_out[4] a_11883_43229# VGND VGND sky130_fd_pr__nfet_01v8 ad=0.08775 pd=0.92 as=0.169 ps=1.82 w=0.65 l=0.15
X1156 VGND halfN/xq1.A a_4365_42711# VGND sky130_fd_pr__nfet_01v8 ad=0.1092 pd=1.36 as=0.0813 ps=0.83 w=0.42 l=0.15
X1157 halfP/RDA.R1_39 halfP/RDA.R2_38 VGND sky130_fd_pr__res_xhigh_po_0p35 l=30.3
X1158 halfP/RDA.R1_25 halfP/xq4.X VGND sky130_fd_pr__res_xhigh_po_0p35 l=30.3
X1159 a_25587_43077# a_24805_42711# a_25503_43077# VDPWR sky130_fd_pr__pfet_01v8_hvt ad=0.0882 pd=0.84 as=0.0567 ps=0.69 w=0.42 l=0.15
X1160 a_26119_41079# halfP/xq4.B VGND VGND sky130_fd_pr__nfet_01v8 ad=0.08775 pd=0.92 as=0.169 ps=1.82 w=0.65 l=0.15
X1161 a_17026_24748# halfP/RIN.R2_1 halfP/CM1.C2 VGND sky130_fd_pr__nfet_01v8 ad=2.22 pd=12.37 as=2.22 ps=12.37 w=12 l=3
X1162 VDPWR a_9954_39570# a_12294_39596# VDPWR sky130_fd_pr__pfet_01v8 ad=0.33 pd=2.66 as=0.15 ps=1.3 w=1 l=1
X1163 a_9767_43229# halfN/obuf5.A VDPWR VDPWR sky130_fd_pr__pfet_01v8_hvt ad=0.26 pd=2.52 as=0.135 ps=1.27 w=1 l=0.15
X1164 VDPWR a_17930_42141# a_17857_42167# VDPWR sky130_fd_pr__pfet_01v8_hvt ad=0.17887 pd=1.26 as=0.07665 ps=0.785 w=0.42 l=0.15
X1165 halfP/obuf5.A a_18815_43229# VDPWR VDPWR sky130_fd_pr__pfet_01v8_hvt ad=0.26 pd=2.52 as=0.135 ps=1.27 w=1 l=0.15
X1166 halfP/CM1.C2 a_19300_24748# VDPWR VDPWR sky130_fd_pr__pfet_01v8 ad=0.74 pd=4.37 as=0.74 ps=4.37 w=4 l=2
X1167 a_17566_39236# a_15786_39096# VGND VGND sky130_fd_pr__nfet_01v8 ad=0.075 pd=0.8 as=0.165 ps=1.66 w=0.5 l=1
X1168 VGND clk a_24639_40535# VGND sky130_fd_pr__nfet_01v8 ad=0.0567 pd=0.69 as=0.1092 ps=1.36 w=0.42 l=0.15
X1169 a_15814_42141# a_15646_42167# VDPWR VDPWR sky130_fd_pr__pfet_01v8_hvt ad=0.1095 pd=1.075 as=0.17887 ps=1.26 w=0.75 l=0.15
X1170 VGND halfN/mon.A VGND VGND sky130_fd_pr__nfet_01v8 ad=0.49 pd=3.5 as=0 ps=0 w=1.4 l=2.86
X1171 a_26369_40785# halfP/obuf3.A VDPWR VDPWR sky130_fd_pr__pfet_01v8_hvt ad=0.135 pd=1.27 as=0.135 ps=1.27 w=1 l=0.15
X1172 a_14183_42685# halfN/mon.A VGND VGND sky130_fd_pr__nfet_01v8 ad=0.169 pd=1.82 as=0.08775 ps=0.92 w=0.65 l=0.15
X1173 a_15646_42167# a_15373_42173# a_15561_42167# VDPWR sky130_fd_pr__pfet_01v8_hvt ad=0.06825 pd=0.745 as=0.05775 ps=0.695 w=0.42 l=0.15
X1174 a_17026_24748# RB.R2_1 VGND VGND sky130_fd_pr__nfet_01v8 ad=0.37 pd=2.37 as=0.37 ps=2.37 w=2 l=2
X1175 VGND a_9954_39096# a_11334_39236# VGND sky130_fd_pr__nfet_01v8 ad=0.165 pd=1.66 as=0.075 ps=0.8 w=0.5 l=1
X1176 VGND a_25503_43077# a_25671_42979# VGND sky130_fd_pr__nfet_01v8 ad=0.08775 pd=0.92 as=0.169 ps=1.82 w=0.65 l=0.15
X1177 uio_out[5] a_10411_41597# VDPWR VDPWR sky130_fd_pr__pfet_01v8_hvt ad=0.135 pd=1.27 as=0.26 ps=2.52 w=1 l=0.15
X1178 a_3185_39991# halfN/obuf5.A VDPWR VDPWR sky130_fd_pr__pfet_01v8_hvt ad=0.135 pd=1.27 as=0.135 ps=1.27 w=1 l=0.15
X1179 a_4365_42545# a_3811_42385# a_4018_42444# VGND sky130_fd_pr__special_nfet_01v8 ad=0.0813 pd=0.83 as=0.0621 ps=0.705 w=0.36 l=0.15
X1180 VDPWR a_12967_42685# a_12974_42985# VDPWR sky130_fd_pr__pfet_01v8_hvt ad=0.0864 pd=0.91 as=0.1664 ps=1.8 w=0.64 l=0.15
X1181 VDPWR a_10411_41597# uio_out[5] VDPWR sky130_fd_pr__pfet_01v8_hvt ad=0.135 pd=1.27 as=0.135 ps=1.27 w=1 l=0.15
X1182 a_3769_40901# a_3431_40687# VDPWR VDPWR sky130_fd_pr__pfet_01v8_hvt ad=0.0882 pd=0.84 as=0.1113 ps=1.37 w=0.42 l=0.15
X1183 VGND a_26119_43255# halfP/xq0.X VGND sky130_fd_pr__nfet_01v8 ad=0.208 pd=1.94 as=0.25025 ps=1.42 w=0.65 l=0.15
X1184 a_12959_42399# a_13250_42289# a_13201_42167# VDPWR sky130_fd_pr__pfet_01v8_hvt ad=0.0567 pd=0.69 as=0.0882 ps=0.84 w=0.42 l=0.15
X1185 a_25246_42141# a_25078_42167# VGND VGND sky130_fd_pr__nfet_01v8 ad=0.0989 pd=0.995 as=0.12095 ps=1.085 w=0.64 l=0.15
X1186 halfN/RDA.R1_41 halfN/RDA.R2_40 VGND sky130_fd_pr__res_xhigh_po_0p35 l=30.3
X1187 VGND halfP/obuf5.A a_19255_43255# VGND sky130_fd_pr__nfet_01v8 ad=0.08775 pd=0.92 as=0.169 ps=1.82 w=0.65 l=0.15
X1188 halfP/RDA.R1_3 halfP/RDA.R2_2 VGND sky130_fd_pr__res_xhigh_po_0p35 l=30.3
X1189 halfP/RDA.R1_43 VGND VGND sky130_fd_pr__res_xhigh_po_0p35 l=30.3
X1190 uo_out[0] a_19255_43255# VGND VGND sky130_fd_pr__nfet_01v8 ad=0.08775 pd=0.92 as=0.08775 ps=0.92 w=0.65 l=0.15
X1191 a_3947_42545# a_3811_42385# a_3527_42399# VDPWR sky130_fd_pr__pfet_01v8_hvt ad=0.1095 pd=1.075 as=0.0567 ps=0.69 w=0.42 l=0.15
X1192 halfP/xq2.B a_25671_42141# VGND VGND sky130_fd_pr__nfet_01v8 ad=0.169 pd=1.82 as=0.08775 ps=0.92 w=0.65 l=0.15
X1193 halfP/xq2.B a_25671_42141# VDPWR VDPWR sky130_fd_pr__pfet_01v8_hvt ad=0.26 pd=2.52 as=0.135 ps=1.27 w=1 l=0.15
X1194 VDPWR halfP/xq2.B a_26369_42167# VDPWR sky130_fd_pr__pfet_01v8_hvt ad=0.26 pd=2.52 as=0.135 ps=1.27 w=1 l=0.15
X1195 halfP/RDA.R1_41 halfP/RIN.R2_1 VGND sky130_fd_pr__res_xhigh_po_0p35 l=30.3
X1196 a_24310_24722# RB.R2_1 a_24244_26120# VGND sky130_fd_pr__nfet_01v8 ad=0.1386 pd=1.5 as=0.1386 ps=1.5 w=0.42 l=8
X1197 a_19006_39596# a_15306_39570# VDPWR VDPWR sky130_fd_pr__pfet_01v8 ad=0.15 pd=1.3 as=0.33 ps=2.66 w=1 l=1
X1198 uio_out[4] a_11883_43229# VGND VGND sky130_fd_pr__nfet_01v8 ad=0.08775 pd=0.92 as=0.08775 ps=0.92 w=0.65 l=0.15
X1199 uo_out[0] a_19255_43255# VDPWR VDPWR sky130_fd_pr__pfet_01v8_hvt ad=0.135 pd=1.27 as=0.135 ps=1.27 w=1 l=0.15
X1200 VDPWR halfP/obuf5.A a_26201_39991# VDPWR sky130_fd_pr__pfet_01v8_hvt ad=0.135 pd=1.27 as=0.135 ps=1.27 w=1 l=0.15
X1201 a_4365_41457# a_3818_41201# a_4018_41356# VDPWR sky130_fd_pr__pfet_01v8_hvt ad=0.05775 pd=0.695 as=0.06825 ps=0.745 w=0.42 l=0.15
X1202 VDPWR a_9954_39570# a_12774_39596# VDPWR sky130_fd_pr__pfet_01v8 ad=0.33 pd=2.66 as=0.15 ps=1.3 w=1 l=1
X1203 VGND a_3431_42399# halfN/xq2.B VGND sky130_fd_pr__nfet_01v8 ad=0.08775 pd=0.92 as=0.169 ps=1.82 w=0.65 l=0.15
X1204 a_3431_42399# a_3527_42399# VDPWR VDPWR sky130_fd_pr__pfet_01v8_hvt ad=0.27 pd=2.54 as=0.135 ps=1.27 w=1 l=0.15
X1205 a_25587_42167# a_24805_42173# a_25503_42167# VDPWR sky130_fd_pr__pfet_01v8_hvt ad=0.0882 pd=0.84 as=0.0567 ps=0.69 w=0.42 l=0.15
X1206 VDPWR a_4018_41356# a_3947_41457# VDPWR sky130_fd_pr__pfet_01v8_hvt ad=0.17887 pd=1.26 as=0.1095 ps=1.075 w=0.75 l=0.15
X1207 uo_out[2] a_18611_41623# VDPWR VDPWR sky130_fd_pr__pfet_01v8_hvt ad=0.135 pd=1.27 as=0.135 ps=1.27 w=1 l=0.15
X1208 VDPWR a_25503_41989# a_25671_41891# VDPWR sky130_fd_pr__pfet_01v8_hvt ad=0.135 pd=1.27 as=0.27 ps=2.54 w=1 l=0.15
X1209 a_24805_41085# a_24639_41085# VDPWR VDPWR sky130_fd_pr__pfet_01v8_hvt ad=0.1664 pd=1.8 as=0.0864 ps=0.91 w=0.64 l=0.15
X1210 a_18046_39236# a_15786_39096# VGND VGND sky130_fd_pr__nfet_01v8 ad=0.075 pd=0.8 as=0.165 ps=1.66 w=0.5 l=1
X1211 a_16021_43255# halfP/dff4.D VGND VGND sky130_fd_pr__nfet_01v8 ad=0.0813 pd=0.83 as=0.1092 ps=1.36 w=0.42 l=0.15
X1212 uio_out[3] a_12067_42685# VGND VGND sky130_fd_pr__nfet_01v8 ad=0.08775 pd=0.92 as=0.08775 ps=0.92 w=0.65 l=0.15
X1213 a_3947_41623# a_3818_41897# a_3527_41597# VGND sky130_fd_pr__special_nfet_01v8 ad=0.0989 pd=0.995 as=0.0684 ps=0.74 w=0.36 l=0.15
X1214 VDPWR a_18611_41623# uo_out[2] VDPWR sky130_fd_pr__pfet_01v8_hvt ad=0.26 pd=2.52 as=0.135 ps=1.27 w=1 l=0.15
X1215 VDPWR a_3811_41597# a_3818_41897# VDPWR sky130_fd_pr__pfet_01v8_hvt ad=0.0864 pd=0.91 as=0.1664 ps=1.8 w=0.64 l=0.15
X1216 VGND a_9954_39096# a_11814_39236# VGND sky130_fd_pr__nfet_01v8 ad=0.165 pd=1.66 as=0.075 ps=0.8 w=0.5 l=1
X1217 a_11681_42545# a_11134_42289# a_11334_42444# VDPWR sky130_fd_pr__pfet_01v8_hvt ad=0.05775 pd=0.695 as=0.06825 ps=0.745 w=0.42 l=0.15
X1218 a_2829_41873# halfN/xq3.B VDPWR VDPWR sky130_fd_pr__pfet_01v8_hvt ad=0.135 pd=1.27 as=0.26 ps=2.52 w=1 l=0.15
X1219 halfN/RIN.R1_0 ua[1] VGND sky130_fd_pr__res_xhigh_po_0p35 l=4.3
X1220 VGND a_16955_42711# uo_out[4] VGND sky130_fd_pr__nfet_01v8 ad=0.08775 pd=0.92 as=0.08775 ps=0.92 w=0.65 l=0.15
X1221 VDPWR a_11334_42444# a_11263_42545# VDPWR sky130_fd_pr__pfet_01v8_hvt ad=0.17887 pd=1.26 as=0.1095 ps=1.075 w=0.75 l=0.15
X1222 a_15646_42167# a_15207_42173# a_15561_42167# VGND sky130_fd_pr__special_nfet_01v8 ad=0.0621 pd=0.705 as=0.0813 ps=0.83 w=0.36 l=0.15
X1223 a_11311_41597# clk VGND VGND sky130_fd_pr__nfet_01v8 ad=0.1092 pd=1.36 as=0.0567 ps=0.69 w=0.42 l=0.15
X1224 a_17566_39596# a_15306_39570# VDPWR VDPWR sky130_fd_pr__pfet_01v8 ad=0.15 pd=1.3 as=0.33 ps=2.66 w=1 l=1
X1225 a_4194_39991# a_3947_40369# VDPWR VDPWR sky130_fd_pr__pfet_01v8_hvt ad=0.07665 pd=0.785 as=0.17887 ps=1.26 w=0.42 l=0.15
X1226 a_15922_43077# a_15649_42711# a_15837_42711# VDPWR sky130_fd_pr__pfet_01v8_hvt ad=0.06825 pd=0.745 as=0.05775 ps=0.695 w=0.42 l=0.15
X1227 VDPWR a_3431_41775# halfN/xq3.B VDPWR sky130_fd_pr__pfet_01v8_hvt ad=0.135 pd=1.27 as=0.26 ps=2.52 w=1 l=0.15
X1228 a_25629_41457# a_24639_41085# a_25503_41079# VGND sky130_fd_pr__special_nfet_01v8 ad=0.066 pd=0.745 as=0.0684 ps=0.74 w=0.36 l=0.15
X1229 RBT.R1_6 VGND VGND sky130_fd_pr__res_xhigh_po_0p35 l=4.38
X1230 a_10874_43532# a_10674_43377# a_11023_43621# VGND sky130_fd_pr__special_nfet_01v8 ad=0.0621 pd=0.705 as=0.0696 ps=0.765 w=0.36 l=0.15
X1231 VDPWR a_9954_39570# a_11334_39596# VDPWR sky130_fd_pr__pfet_01v8 ad=0.33 pd=2.66 as=0.15 ps=1.3 w=1 l=1
X1232 a_3017_40535# halfN/xq5.B halfN/xq5.X VGND sky130_fd_pr__nfet_01v8 ad=0.08775 pd=0.92 as=0.25025 ps=1.42 w=0.65 l=0.15
X1233 a_11518_41597# a_11318_41897# a_11667_41623# VGND sky130_fd_pr__special_nfet_01v8 ad=0.0621 pd=0.705 as=0.0696 ps=0.765 w=0.36 l=0.15
X1234 VGND a_25671_41053# a_25629_41457# VGND sky130_fd_pr__nfet_01v8 ad=0.1092 pd=1.36 as=0.066 ps=0.745 w=0.42 l=0.15
X1235 uo_out[3] a_17139_43255# VGND VGND sky130_fd_pr__nfet_01v8 ad=0.08775 pd=0.92 as=0.08775 ps=0.92 w=0.65 l=0.15
X1236 halfP/RDA.R1_5 halfP/RIN.R2_1 VGND sky130_fd_pr__res_xhigh_po_0p35 l=30.3
X1237 a_25204_40535# a_24805_40535# a_25078_40901# VGND sky130_fd_pr__special_nfet_01v8 ad=0.0696 pd=0.765 as=0.0621 ps=0.705 w=0.36 l=0.15
X1238 a_24993_40535# halfP/obuf3.A VDPWR VDPWR sky130_fd_pr__pfet_01v8_hvt ad=0.05775 pd=0.695 as=0.1092 ps=1.36 w=0.42 l=0.15
X1239 VDPWR a_9767_43229# uio_out[7] VDPWR sky130_fd_pr__pfet_01v8_hvt ad=0.135 pd=1.27 as=0.135 ps=1.27 w=1 l=0.15
X1240 VDPWR a_3811_40509# a_3818_40809# VDPWR sky130_fd_pr__pfet_01v8_hvt ad=0.0864 pd=0.91 as=0.1664 ps=1.8 w=0.64 l=0.15
X1241 VGND a_3811_41297# a_3818_41201# VGND sky130_fd_pr__nfet_01v8 ad=0.0567 pd=0.69 as=0.1092 ps=1.36 w=0.42 l=0.15
X1242 VDPWR a_3811_40209# a_3818_40113# VDPWR sky130_fd_pr__pfet_01v8_hvt ad=0.0864 pd=0.91 as=0.1664 ps=1.8 w=0.64 l=0.15
X1243 a_4018_40268# a_3811_40209# a_4194_39991# VDPWR sky130_fd_pr__pfet_01v8_hvt ad=0.06825 pd=0.745 as=0.07665 ps=0.785 w=0.42 l=0.15
X1244 a_12587_42863# a_12683_42685# VGND VGND sky130_fd_pr__nfet_01v8 ad=0.169 pd=1.82 as=0.08775 ps=0.92 w=0.65 l=0.15
X1245 a_15588_41623# a_15189_41623# a_15462_41989# VGND sky130_fd_pr__special_nfet_01v8 ad=0.0696 pd=0.765 as=0.0621 ps=0.705 w=0.36 l=0.15
X1246 VGND halfN/dff1.D VGND VGND sky130_fd_pr__nfet_01v8 ad=0.49 pd=3.5 as=0 ps=0 w=1.4 l=2.86
X1247 VGND a_4018_41356# a_3947_41457# VGND sky130_fd_pr__nfet_01v8 ad=0.12095 pd=1.085 as=0.0989 ps=0.995 w=0.64 l=0.15
C0 halfN/RDA.R2_40 halfN/RIN.R2_1 0.16817f
C1 uo_out[1] halfP/xq3.A 0.01828f
C2 a_24993_40535# a_24805_40535# 0.06685f
C3 halfP/RDA.R1_29 halfP/RDA.R1_31 0.15162f
C4 VDPWR a_24993_41623# 0.05353f
C5 halfP/xq3.A a_16347_43077# 0.03043f
C6 a_17783_43261# halfP/dff5.D 0.09549f
C7 irst.Y halfP/CM1.C2 2.57426f
C8 VDPWR tie_oe1.LO 0.29806f
C9 a_15373_42173# halfP/dff2.D 0.16286f
C10 uio_oe[3] halfN/xq0.A 0.03461f
C11 a_24639_41623# a_24639_42173# 0.01911f
C12 a_16531_43255# a_16699_43229# 0.20625f
C13 clk halfN/obuf5.A 0.91166f
C14 uo_out[3] halfP/xq3.A 0.01919f
C15 halfP/xq2.B VDPWR 0.22607f
C16 a_12967_42685# a_13521_42711# 0.04548f
C17 a_18815_43229# a_17949_43261# 0.01914f
C18 halfN/RDA.R1_33 halfN/RDA.R1_35 0.15162f
C19 a_13243_42385# halfN/dff6.D 0.05101f
C20 halfP/dff4.D uo_out[6] 0.09409f
C21 halfP/CM1.C2 RBT.R1_4 0.01305f
C22 a_26119_41873# halfP/xq3.B 0.22941f
C23 a_25503_39991# a_25246_39965# 0.0205f
C24 a_3811_43473# a_4365_43633# 0.04548f
C25 VDPWR a_16955_42711# 0.32573f
C26 a_4018_40268# a_3818_40113# 0.07623f
C27 tie_oe2.LO uio_oe[0] 0.04901f
C28 halfP/xq1.B a_26119_42961# 0.22941f
C29 a_24639_41623# halfP/xq3.A 0.09708f
C30 halfP/xq4.X halfP/xq0.X 0.12047f
C31 uio_oe[0] halfN/xq3.A 0.02346f
C32 uio_out[4] halfN/xq0.A 0.02069f
C33 VDPWR halfN/xq2.A 0.78417f
C34 halfP/xq2.A halfP/xq0.X 0.01069f
C35 a_2829_40785# halfN/xq5.B 0.03769f
C36 a_12959_42399# a_13250_42289# 0.1112f
C37 a_3947_40535# a_3527_40509# 0.0205f
C38 halfN/dff1.D halfN/dff3.D 0.09513f
C39 halfN/xq3.X halfN/xq3.B 0.01331f
C40 VDPWR halfP/xq4.B 0.22607f
C41 a_12967_42685# uio_out[1] 0.01536f
C42 VDPWR a_25246_41735# 0.14313f
C43 halfN/xq2.X halfN/xq0.X 0.124f
C44 halfN/xq4.B halfN/obuf6.A 0.20854f
C45 VDPWR halfN/dff5.D 0.9079f
C46 halfP/xq2.B a_26369_42167# 0.03769f
C47 a_3431_42863# a_3811_42685# 0.02545f
C48 RBT.R2_0 halfN/CM1.C2 1.53865f
C49 RB.R2_1 halfP/RIN.R2_1 1.23801f
C50 a_13243_42385# halfN/dff4.D 0.03816f
C51 halfN/xq6.B halfN/xq6.X 0.01329f
C52 a_24993_42167# a_24639_42173# 0.04548f
C53 halfP/RDA.R2_38 halfP/xq6.X 0.15206f
C54 clk a_10674_43377# 0.01782f
C55 VDPWR a_24993_39991# 0.05353f
C56 RB.R2_1 ua[1] 0.36602f
C57 halfP/xq2.B halfP/xq1.B 0.01239f
C58 VDPWR a_3431_42863# 0.31659f
C59 VDPWR halfN/xq3.B 0.22607f
C60 a_10667_43473# a_11221_43633# 0.04548f
C61 halfN/RIN.R2_1 halfN/xq0.X 0.9475f
C62 VDPWR a_24805_42173# 0.25972f
C63 halfP/xq1.A halfP/xq2.A 1.71331f
C64 uo_out[1] uo_out[0] 0.17454f
C65 a_15462_41989# a_15630_41735# 0.16113f
C66 halfP/xq2.X halfP/xq4.X 0.10632f
C67 a_15306_39570# halfP/CM1.C2 0.13647f
C68 halfN/dff5.D a_11318_41897# 0.06364f
C69 a_24993_41079# a_25078_41079# 0.02068f
C70 VDPWR a_24639_42711# 0.5153f
C71 VDPWR a_25503_39991# 0.15664f
C72 VDPWR uio_out[5] 0.5296f
C73 VDPWR uio_oe[7] 0.10718f
C74 VDPWR a_3431_40687# 0.31659f
C75 a_15646_42167# a_15814_42141# 0.16113f
C76 VDPWR a_11263_42545# 0.14792f
C77 halfN/obuf6.A halfN/xq2.A 0.05469f
C78 halfN/xq1.B halfN/xq1.A 0.20854f
C79 VDPWR a_11681_42545# 0.05353f
C80 a_24805_41085# a_25671_41053# 0.01914f
C81 RBT.R2_0 halfN/RIN.R2_1 1.20106f
C82 clk uo_out[6] 0.89547f
C83 halfN/obuf3.A a_3811_40509# 0.09534f
C84 clk halfN/dff2.D 0.19853f
C85 ua[0] halfP/xq0.X 0.02863f
C86 a_25671_43229# halfP/xq0.A 0.02962f
C87 a_11318_41897# uio_out[5] 0.01277f
C88 a_4018_41356# a_3947_41457# 0.16113f
C89 clk uio_out[1] 0.89547f
C90 VDPWR halfN/obuf5.A 0.7563f
C91 uio_oe[2] halfN/xq0.A 0.02754f
C92 a_4018_42444# a_4365_42545# 0.02068f
C93 uo_out[4] halfP/xq1.A 0.02233f
C94 clk a_3811_43473# 0.15438f
C95 halfP/obuf6.A a_24639_41085# 0.09427f
C96 VDPWR a_24993_41079# 0.05353f
C97 halfN/RDA.R1_7 halfN/RDA.R1_9 0.15162f
C98 a_15207_42173# a_15373_42173# 0.56916f
C99 RBT.R2_0 a_19300_24748# 3.97272f
C100 halfP/RDA.R2_28 halfP/RIN.R2_1 0.16817f
C101 VDPWR a_25246_42141# 0.14313f
C102 halfP/RIN.R2_1 a_24310_24722# 0.04096f
C103 a_13379_42545# a_12959_42399# 0.0205f
C104 uio_out[3] halfN/xq1.A 0.02233f
C105 VDPWR a_24805_40535# 0.25972f
C106 a_12499_43487# a_12919_43633# 0.0205f
C107 a_15483_42711# halfP/xq0.A 0.02137f
C108 halfN/xq2.B halfN/xq2.A 0.20854f
C109 halfN/xq0.X halfN/xq4.X 0.12047f
C110 a_15667_43261# halfP/xq3.A 0.01805f
C111 uio_out[5] halfN/obuf6.A 0.0229f
C112 halfN/RDA.R1_15 halfN/RDA.R1_17 0.15162f
C113 uio_oe[7] halfN/obuf6.A 0.04791f
C114 halfP/dff3.D halfP/dff5.D 0.68035f
C115 VDPWR a_2829_40785# 0.16163f
C116 halfP/RDA.R1_13 halfP/RDA.R1_11 0.15162f
C117 VDPWR a_3818_43377# 0.25972f
C118 uio_oe[0] halfN/obuf3.A 0.04633f
C119 halfP/xq2.X ua[0] 0.03655f
C120 clk halfP/dff4.D 0.26512f
C121 VDPWR a_17677_42167# 0.05353f
C122 a_3818_40809# a_3431_40687# 0.01914f
C123 a_17677_42167# a_17323_42173# 0.04548f
C124 RT.R2_1 VDPWR 0.15825f
C125 a_14183_42685# halfN/mon.A 0.16227f
C126 clk a_12967_42685# 0.18763f
C127 halfP/obuf6.A halfP/xq2.A 0.05469f
C128 VDPWR a_10674_43377# 0.25945f
C129 uo_out[1] halfP/xq0.A 0.02024f
C130 uo_out[0] a_19255_43255# 0.23139f
C131 a_13450_42444# halfN/dff6.D 0.0242f
C132 a_3431_41775# a_3527_41597# 0.20625f
C133 halfN/xq2.B halfN/xq3.B 0.01221f
C134 a_2799_42896# halfN/xq1.X 0.1167f
C135 a_2799_41053# halfN/xq4.X 0.11648f
C136 uo_out[7] halfP/mon.A 0.01357f
C137 halfP/xq0.A a_16347_43077# 0.02106f
C138 a_13981_41623# a_13427_41597# 0.04548f
C139 rst_n halfP/RIN.R2_1 0.03273f
C140 a_15922_43077# a_16090_42823# 0.16113f
C141 halfP/xq5.X a_26119_40785# 0.11653f
C142 halfN/mon.A a_13981_41623# 0.08378f
C143 VDPWR a_2799_43229# 0.14245f
C144 uo_out[3] halfP/xq0.A 0.02069f
C145 halfN/xq4.B a_2799_41053# 0.22941f
C146 rst_n ua[1] 1.65905f
C147 halfN/RDA.R1_5 halfN/RDA.R1_3 0.15162f
C148 a_3811_40209# a_3947_40369# 0.09081f
C149 a_19300_24748# halfP/xq4.X 0.02304f
C150 a_12499_43487# uio_out[3] 0.01053f
C151 halfP/mon.A a_15786_39096# 0.10733f
C152 a_18355_42141# halfP/obuf3.A 0.09379f
C153 uio_out[3] halfN/xq3.A 0.11342f
C154 VDPWR a_11027_41597# 0.16124f
C155 VDPWR a_10874_43532# 0.19596f
C156 VDPWR a_13521_42711# 0.05353f
C157 clk a_14839_42711# 0.06312f
C158 a_13981_41623# a_13434_41897# 0.06685f
C159 uo_out[1] a_17489_42173# 0.01568f
C160 halfN/dff5.D a_9954_39096# 0.30825f
C161 clk a_16679_42167# 0.03677f
C162 halfP/RDA.R2_20 halfP/RDA.R2_22 0.15162f
C163 rst_n halfP/xq5.X 0.17644f
C164 halfN/dff4.D a_13450_42444# 0.01434f
C165 a_25503_42167# halfP/xq2.A 0.02237f
C166 halfP/dff3.D halfP/dff6.D 0.49963f
C167 halfN/xq0.X halfN/xq2.A 0.01069f
C168 a_11311_41597# a_11518_41597# 0.16041f
C169 a_16515_42979# a_15649_42711# 0.01914f
C170 a_16515_42979# halfP/obuf6.A 0.08626f
C171 a_3811_43473# a_3811_42685# 0.01911f
C172 VDPWR uo_out[6] 0.51711f
C173 VDPWR a_4365_40369# 0.05353f
C174 uo_out[4] halfP/obuf6.A 0.14024f
C175 VDPWR halfN/dff2.D 0.581f
C176 uo_out[1] a_18795_42167# 0.23093f
C177 a_11318_41897# a_11027_41597# 0.1112f
C178 VDPWR uio_out[1] 0.51711f
C179 halfP/xq3.X halfP/xq6.X 0.10727f
C180 a_25246_41053# halfP/obuf6.A 0.01943f
C181 a_2829_42961# halfN/xq1.X 0.05751f
C182 a_9954_39570# halfN/dff6.D 0.1277f
C183 a_3811_43473# VDPWR 0.5153f
C184 halfP/RDA.R1_5 halfP/RDA.R1_3 0.15162f
C185 a_3818_42289# a_3947_42545# 0.08347f
C186 uio_oe[6] halfN/xq3.A 0.02972f
C187 a_25246_42823# halfP/xq1.A 0.02017f
C188 halfP/dff4.D a_15887_41989# 0.02619f
C189 clk uo_out[2] 0.20499f
C190 VDPWR a_4365_43633# 0.05353f
C191 halfP/RDA.R2_20 halfP/RIN.R2_1 0.01627f
C192 a_26369_40785# halfP/xq5.X 0.05741f
C193 RB.R2_1 a_24310_24722# 0.42712f
C194 a_2799_42141# halfN/xq2.X 0.11649f
C195 halfP/dff4.D VDPWR 0.71141f
C196 halfN/dff2.D a_13634_41597# 0.02145f
C197 irst.Y halfP/RIN.R2_1 0.65235f
C198 tie_oe6.LO uio_oe[4] 0.04941f
C199 a_3818_41201# a_4365_41457# 0.06685f
C200 VDPWR tie_oe7.LO 0.30067f
C201 halfN/dff4.D a_9954_39570# 0.13442f
C202 uo_out[5] a_15483_42711# 0.0115f
C203 irst.Y ua[1] 0.40498f
C204 a_19300_24748# ua[0] 0.48222f
C205 a_24805_42711# a_25246_42823# 0.08347f
C206 a_12967_42685# VDPWR 0.5282f
C207 uio_oe[1] tie_oe1.LO 0.04613f
C208 uo_out[0] halfP/obuf5.A 0.14229f
C209 VDPWR a_3947_41457# 0.14313f
C210 halfP/xq2.B halfP/xq2.A 0.20854f
C211 RBT.R1_4 ua[1] 0.01193f
C212 VDPWR a_4018_41356# 0.19701f
C213 a_3811_42385# a_4365_42545# 0.04548f
C214 halfN/obuf5.A halfN/xq0.X 0.01069f
C215 halfN/dff1.D halfN/dff5.D 0.11246f
C216 uio_oe[5] halfN/xq3.A 0.01416f
C217 VDPWR a_25078_43077# 0.19701f
C218 a_15306_39570# halfP/mon.A 0.17869f
C219 halfN/RDA.R1_29 halfN/RDA.R1_27 0.15162f
C220 RB.R2_1 rst_n 0.02658f
C221 VDPWR a_11865_41623# 0.05353f
C222 VDPWR a_25503_41989# 0.15812f
C223 uio_out[3] a_12067_42685# 0.22589f
C224 VDPWR a_14839_42711# 0.35062f
C225 VDPWR a_16679_42167# 0.32715f
C226 a_24805_41623# halfP/xq3.A 0.17417f
C227 uio_in[6] uio_in[5] 0.01551f
C228 halfN/obuf3.A a_10227_42141# 0.2187f
C229 a_15667_43261# halfP/xq0.A 0.04609f
C230 halfP/xq4.X halfP/xq4.B 0.0133f
C231 halfP/xq0.B halfP/xq0.X 0.01528f
C232 a_26119_39991# halfP/xq6.B 0.22941f
C233 a_24639_39997# a_24993_39991# 0.04548f
C234 VDPWR a_24993_40535# 0.05353f
C235 a_18187_42167# a_17489_42173# 0.1112f
C236 halfP/obuf3.A a_25671_40803# 0.02906f
C237 a_13250_42289# halfN/dff2.D 0.16286f
C238 a_18046_39596# halfP/dff2.D 0.01187f
C239 a_16239_42141# halfP/xq3.A 0.09349f
C240 a_4018_42444# a_3818_42289# 0.07623f
C241 a_10931_41775# a_11311_41597# 0.02545f
C242 a_3818_41201# a_3818_41897# 0.01361f
C243 a_25078_42167# a_24639_42173# 0.16041f
C244 a_11318_41897# a_11865_41623# 0.06685f
C245 VDPWR halfP/xq3.X 0.33771f
C246 clk a_3811_42685# 0.15601f
C247 halfN/xq0.A a_3431_43487# 0.02962f
C248 clk a_12783_43473# 0.2006f
C249 halfN/dff4.D a_13174_42685# 0.02233f
C250 halfP/dff3.D a_17139_41623# 0.07007f
C251 a_2799_43229# halfN/xq0.B 0.22941f
C252 clk a_15887_41989# 0.01623f
C253 a_25503_39991# a_24639_39997# 0.03079f
C254 halfN/RDA.R1_25 halfN/RDA.R1_23 0.15162f
C255 a_24805_42173# halfP/xq2.A 0.17264f
C256 halfN/dff6.D uio_out[2] 0.01244f
C257 a_3811_40209# a_3818_40113# 0.56916f
C258 VDPWR halfN/xq5.B 0.22607f
C259 a_3947_41457# halfN/obuf6.A 0.01943f
C260 a_4018_41597# VDPWR 0.19701f
C261 halfP/obuf6.A a_24805_41085# 0.17223f
C262 clk VDPWR 6.12322f
C263 a_5356_24748# RB.R2_1 2.21721f
C264 uio_out[7] halfN/xq0.A 0.02112f
C265 VDPWR halfP/xq6.X 0.48123f
C266 a_2799_43229# halfN/xq0.X 0.1188f
C267 a_25671_39965# halfP/xq6.B 0.07523f
C268 uio_in[4] uio_in[5] 0.01551f
C269 clk a_17323_42173# 0.16248f
C270 a_4018_41356# halfN/obuf6.A 0.01515f
C271 a_25671_42979# a_25671_43229# 0.01302f
C272 halfP/RDA.R1_25 halfP/RDA.R1_27 0.15162f
C273 a_16955_42711# uo_out[4] 0.22589f
C274 VDPWR uo_out[2] 0.5296f
C275 uo_out[2] a_17323_42173# 0.02827f
C276 a_24639_41085# a_24993_41079# 0.04548f
C277 a_3818_41897# a_3431_41775# 0.01914f
C278 VDPWR a_3185_41873# 0.01434f
C279 halfN/RDA.R2_40 halfN/RDA.R2_38 0.15162f
C280 a_15377_41623# a_15189_41623# 0.06685f
C281 uo_out[1] a_17949_43261# 0.01551f
C282 halfN/xq0.A a_4018_43532# 0.01584f
C283 RT.R2_1 RBT.R2_0 0.03704f
C284 halfP/xq3.A halfP/xq3.B 0.20854f
C285 VDPWR a_3185_39991# 0.01434f
C286 halfN/dff2.D a_9954_39096# 0.09222f
C287 a_15814_42141# a_16071_42167# 0.0205f
C288 RARR.R1_3 halfP/CM1.C2 0.17445f
C289 halfN/RDA.R1_19 halfN/RDA.R1_21 0.15162f
C290 a_24639_41623# a_25671_41891# 0.02545f
C291 halfN/dff4.D uio_out[2] 0.05796f
C292 clk a_11318_41897# 0.02201f
C293 a_3818_42985# halfN/xq1.A 0.17659f
C294 halfN/CM1.C2 halfN/xq6.X 0.0215f
C295 halfP/dff2.D halfP/dff5.D 0.11338f
C296 RB.R2_1 irst.Y 3.16112f
C297 halfP/dff5.D a_17930_42141# 0.02581f
C298 uio_oe[1] halfN/obuf5.A 0.02403f
C299 a_25671_40803# a_25671_41053# 0.01302f
C300 a_13243_42385# a_12863_42399# 0.02545f
C301 a_3947_43633# a_4018_43532# 0.16113f
C302 VDPWR a_25246_39965# 0.14333f
C303 halfP/dff6.D a_15837_42711# 0.08245f
C304 halfP/mon.A a_16606_39596# 0.01242f
C305 halfP/xq0.A a_16071_42167# 0.02245f
C306 a_25246_42141# halfP/xq2.A 0.01976f
C307 VDPWR a_25078_41079# 0.19701f
C308 a_3811_41597# a_3947_41623# 0.09081f
C309 clk halfN/obuf6.A 0.61844f
C310 halfN/xq2.X halfN/xq6.X 0.10646f
C311 uo_out[2] a_18171_41891# 0.02416f
C312 a_2799_42141# halfN/xq2.A 0.07434f
C313 a_15377_41623# a_15023_41623# 0.04548f
C314 VDPWR halfN/xq3.X 0.36877f
C315 a_19300_24748# a_17026_24748# 0.70727f
C316 halfN/dff5.D halfN/mon.A 0.17011f
C317 halfP/dff1.D halfP/dff5.D 0.11246f
C318 VDPWR a_3811_42685# 0.5153f
C319 halfN/RIN.R2_1 halfN/RDA.R2_8 0.01627f
C320 ui_in[4] ui_in[3] 0.01551f
C321 halfP/dff6.D halfP/dff2.D 0.98981f
C322 a_12783_43473# VDPWR 0.52278f
C323 halfN/RIN.R2_1 halfN/xq6.X 0.246f
C324 halfP/RDA.R2_8 halfP/xq1.X 0.15243f
C325 halfP/xq5.B a_25671_40803# 0.07523f
C326 a_15667_43261# uo_out[5] 0.01534f
C327 VDPWR a_15887_41989# 0.16115f
C328 a_26369_40785# a_26119_40785# 0.01818f
C329 a_25246_43229# halfP/xq0.A 0.02002f
C330 RBT.R2_5 RBT.R2_3 0.15162f
C331 clk a_13250_42289# 0.06802f
C332 VDPWR halfN/RDA.R1_21 0.0106f
C333 a_26119_42961# a_26369_42961# 0.01818f
C334 RT.R2_5 RT.R2_3 0.15162f
C335 a_15667_43261# a_16699_43229# 0.02545f
C336 halfN/xq2.A a_4365_42545# 0.08717f
C337 VDPWR a_17323_42173# 0.52739f
C338 irst.Y a_24310_24722# 0.07869f
C339 halfN/dff1.D halfN/dff2.D 0.34713f
C340 a_15462_41989# halfP/dff6.D 0.02112f
C341 halfN/RIN.R2_1 halfN/RDA.R2_28 0.16817f
C342 a_3431_41775# halfN/xq3.B 0.07523f
C343 uio_oe[4] halfN/obuf5.A 0.01407f
C344 a_4365_41623# a_3818_41897# 0.06685f
C345 uo_out[0] halfP/obuf3.A 0.07344f
C346 a_3811_41297# a_3811_41597# 0.02056f
C347 a_25078_39991# a_24805_39997# 0.07623f
C348 halfP/RDA.R1_1 halfP/RDA.R1_0 0.15162f
C349 halfN/xq0.A uio_out[2] 0.12585f
C350 a_12343_42141# uio_out[2] 0.21743f
C351 a_10843_42399# uio_out[6] 0.0241f
C352 VDPWR a_11318_41897# 0.26596f
C353 uio_in[1] uio_in[0] 0.01551f
C354 VDPWR a_26369_42167# 0.16163f
C355 a_12959_42399# a_13243_42385# 0.03079f
C356 halfP/dff1.D halfP/dff6.D 0.08704f
C357 a_3818_42289# a_3811_42385# 0.56916f
C358 a_18647_43255# uo_out[0] 0.01934f
C359 a_18815_43229# a_17783_43261# 0.02545f
C360 a_16239_42141# halfP/xq0.A 0.04493f
C361 clk a_17139_43255# 0.03997f
C362 halfN/RDA.R1_37 halfN/RDA.R1_35 0.15162f
C363 VDPWR a_13634_41597# 0.20013f
C364 a_17746_41735# uo_out[2] 0.01454f
C365 a_12967_42685# a_13103_42711# 0.09081f
C366 a_3527_40223# a_3947_40369# 0.0205f
C367 halfP/dff3.D a_17489_42173# 0.16457f
C368 a_25503_40901# a_25671_40803# 0.20625f
C369 VDPWR halfP/xq1.B 0.22607f
C370 irst.Y rst_n 0.23824f
C371 a_26369_39991# halfP/xq6.B 0.03769f
C372 a_12974_42985# halfN/dff6.D 0.12549f
C373 halfN/xq6.X halfN/xq4.X 0.10981f
C374 halfP/RDA.R1_37 halfP/RDA.R1_39 0.15162f
C375 VDPWR halfN/obuf6.A 0.70598f
C376 RARR.R1_1 a_9954_39570# 0.04725f
C377 VDPWR a_18171_41891# 0.32239f
C378 uio_out[4] uio_out[5] 0.17546f
C379 a_25246_42823# a_24639_42711# 0.09081f
C380 VDPWR a_3818_40809# 0.25972f
C381 rst_n RBT.R1_4 0.04565f
C382 halfP/dff2.D a_15189_41623# 0.05499f
C383 a_17783_43261# a_17949_43261# 0.56916f
C384 uio_oe[3] halfN/obuf5.A 0.02459f
C385 uo_out[2] a_18003_41989# 0.0161f
C386 uo_out[5] a_16071_42167# 0.01463f
C387 a_10843_42399# a_10747_42399# 0.20625f
C388 a_16531_43255# a_15667_43261# 0.03079f
C389 a_17578_41989# a_17139_41623# 0.16041f
C390 a_18815_43229# halfP/obuf5.A 0.10467f
C391 halfP/xq0.A a_24639_43261# 0.09558f
C392 clk a_13379_42545# 0.01392f
C393 halfN/dff1.D a_11865_41623# 0.08245f
C394 a_10843_42399# a_11134_42289# 0.1112f
C395 a_16090_42823# a_15649_42711# 0.08347f
C396 halfN/xq2.X halfN/xq1.X 4.24835f
C397 a_12974_42985# halfN/dff4.D 0.05593f
C398 a_15462_41989# a_15189_41623# 0.07623f
C399 halfP/dff4.D a_15373_42173# 0.04468f
C400 halfP/obuf5.A halfP/xq6.B 0.20854f
C401 RT.R1_2 RT.R1_0 0.15162f
C402 a_18390_43229# a_17949_43261# 0.08347f
C403 a_5356_24748# irst.Y 0.17243f
C404 VDPWR a_13250_42289# 0.26907f
C405 VDPWR halfN/xq2.B 0.22607f
C406 a_3431_40223# a_3818_40113# 0.01914f
C407 halfN/dff3.D a_9954_39570# 0.11567f
C408 halfN/xq4.B a_3431_41311# 0.07523f
C409 a_15207_42173# halfP/dff6.D 0.05101f
C410 halfP/xq0.A a_16274_43229# 0.02654f
C411 a_3811_41597# halfN/xq3.A 0.09708f
C412 uio_out[7] uio_out[6] 0.17454f
C413 VDPWR a_26369_43255# 0.16163f
C414 halfN/RDA.R1_39 halfN/RDA.R1_37 0.15162f
C415 a_11127_42385# a_11334_42444# 0.16041f
C416 halfN/RIN.R2_1 halfN/xq1.X 0.24984f
C417 a_2799_42896# halfN/xq1.A 0.07434f
C418 clk a_13103_42711# 0.01279f
C419 uio_oe[6] uio_oe[5] 0.28748f
C420 a_3818_42289# a_3818_41897# 0.01371f
C421 a_24805_41085# a_24993_41079# 0.06685f
C422 halfP/xq3.A halfP/xq0.X 0.01069f
C423 clk a_24639_41085# 0.15601f
C424 a_15667_43261# a_16106_43255# 0.16041f
C425 halfN/xq0.X halfN/RDA.R2_2 0.15273f
C426 halfP/dff2.D a_15023_41623# 0.06516f
C427 a_24805_41085# a_24805_40535# 0.01371f
C428 a_4365_40535# a_3811_40509# 0.04548f
C429 halfP/dff4.D a_15630_41735# 0.01026f
C430 a_25503_43077# a_25671_42979# 0.20625f
C431 halfP/xq1.X halfP/xq0.X 4.58764f
C432 clk halfN/dff1.D 0.01242f
C433 RARR.R2_1 RARR.R2_2 0.43335f
C434 VDPWR a_17746_41735# 0.14524f
C435 a_15833_43261# halfP/dff4.D 0.16439f
C436 a_6022_24748# halfN/xq5.X 0.025f
C437 halfP/xq3.X halfP/xq4.X 3.75467f
C438 halfN/xq3.X halfN/xq0.X 0.12143f
C439 VDPWR a_17139_43255# 0.32344f
C440 halfN/dff2.D a_13427_41597# 0.06516f
C441 clk a_24639_39997# 0.15451f
C442 a_10667_43473# uio_out[6] 0.01898f
C443 halfN/CM1.C2 a_9954_39570# 0.13647f
C444 halfN/mon.A halfN/dff2.D 0.19876f
C445 a_3431_40223# halfN/xq6.B 0.07523f
C446 VDPWR a_9954_39096# 0.11063f
C447 uio_out[1] a_13427_41597# 0.02991f
C448 RBT.R1_6 halfP/CM1.C2 0.01305f
C449 a_15462_41989# a_15023_41623# 0.16041f
C450 halfP/xq3.A halfP/xq1.A 0.07914f
C451 a_15649_42711# halfP/dff6.D 0.12549f
C452 VDPWR halfN/xq0.B 0.22607f
C453 clk uio_oe[1] 0.08119f
C454 halfN/mon.A uio_out[1] 0.01038f
C455 VDPWR a_17493_41623# 0.05353f
C456 a_10287_43487# a_10383_43487# 0.20625f
C457 a_12974_42985# a_12683_42685# 0.1112f
C458 halfP/xq4.X halfP/xq6.X 0.10981f
C459 clk halfP/xq2.A 0.35848f
C460 halfP/dff1.D a_17139_41623# 0.05259f
C461 VDPWR a_3185_42961# 0.01434f
C462 a_15306_39570# a_15786_39096# 0.12634f
C463 a_16239_42141# uo_out[5] 0.01401f
C464 VDPWR halfN/xq0.X 0.47931f
C465 a_18795_42167# halfP/obuf3.A 0.2187f
C466 halfN/dff2.D a_13434_41897# 0.05499f
C467 halfN/RDA.R1_19 halfN/RDA.R1_17 0.15162f
C468 halfP/xq2.X halfP/xq1.X 4.24835f
C469 VDPWR a_18003_41989# 0.16124f
C470 uo_out[2] halfP/xq2.A 0.10904f
C471 a_16021_43255# a_16106_43255# 0.02068f
C472 halfP/xq2.X halfP/RDA.R2_14 0.15227f
C473 halfP/RDA.R1_33 halfP/RDA.R1_31 0.15162f
C474 a_26119_43255# VDPWR 0.14245f
C475 a_24639_41085# a_25078_41079# 0.16041f
C476 uio_oe[2] halfN/obuf5.A 0.01453f
C477 clk a_15373_42173# 0.06802f
C478 halfN/xq4.X halfN/xq1.X 0.1039f
C479 VDPWR a_13379_42545# 0.14866f
C480 a_12974_42985# halfN/xq0.A 0.06022f
C481 a_25246_39965# a_24639_39997# 0.09081f
C482 halfP/mon.A a_15377_41623# 0.08378f
C483 halfN/RDA.R1_31 halfN/RDA.R1_33 0.15162f
C484 a_2799_41053# VDPWR 0.14245f
C485 a_3527_40223# a_3818_40113# 0.1112f
C486 a_13337_43633# halfN/dff4.D 0.0852f
C487 a_24805_41623# a_25671_41891# 0.01914f
C488 a_3818_41201# a_3947_41457# 0.08347f
C489 a_17762_42167# halfP/dff5.D 0.0227f
C490 clk a_12403_43487# 0.02065f
C491 a_3818_42289# halfN/xq2.A 0.17264f
C492 a_3811_42685# a_3947_42711# 0.09081f
C493 a_25671_39965# a_24805_39997# 0.01914f
C494 halfN/obuf3.A a_4365_40535# 0.08703f
C495 a_3818_41201# a_4018_41356# 0.07623f
C496 a_25078_40901# a_24639_40535# 0.16041f
C497 a_24639_41623# a_25078_41989# 0.16041f
C498 RBT.R2_0 VDPWR 1.4186f
C499 a_15483_42711# a_16347_43077# 0.03079f
C500 a_3431_41311# a_3431_40687# 0.01302f
C501 clk a_16515_42979# 0.01174f
C502 a_12967_42685# a_12587_42863# 0.02545f
C503 clk uo_out[4] 0.30699f
C504 VDPWR a_3947_42711# 0.14313f
C505 halfP/dff3.D a_17305_41623# 0.06002f
C506 clk a_15630_41735# 0.01041f
C507 uio_out[7] a_10287_43487# 0.0339f
C508 halfP/xq3.X ua[0] 0.04014f
C509 VDPWR a_2829_39991# 0.16163f
C510 VDPWR a_13103_42711# 0.14519f
C511 halfN/xq0.A halfN/xq1.A 0.31342f
C512 uo_out[2] uo_out[4] 0.023f
C513 a_18222_43255# a_17949_43261# 0.07623f
C514 a_4018_40268# halfN/obuf5.A 0.01486f
C515 halfN/obuf6.A halfN/xq0.X 0.01069f
C516 clk a_15833_43261# 0.0638f
C517 VDPWR a_24639_41085# 0.5153f
C518 clk ena 0.01551f
C519 uo_out[0] halfP/xq1.A 0.02513f
C520 a_3947_41457# a_3527_41311# 0.0205f
C521 a_18003_41989# a_18171_41891# 0.20625f
C522 ua[0] halfP/xq6.X 0.22364f
C523 VDPWR halfN/dff1.D 0.45064f
C524 clk uio_oe[4] 0.10941f
C525 a_10843_42399# halfN/xq2.A 0.02342f
C526 a_12683_42685# halfN/xq3.A 0.03043f
C527 halfP/obuf5.A a_25078_39991# 0.01486f
C528 halfP/obuf6.A halfP/xq3.A 2.40041f
C529 a_10843_42399# halfN/dff5.D 0.01082f
C530 VDPWR a_24639_39997# 0.51401f
C531 halfP/CM1.C2 halfN/CM1.C2 0.23792f
C532 a_10667_43473# a_10287_43487# 0.02545f
C533 a_2799_41053# halfN/obuf6.A 0.07434f
C534 a_9767_43229# uio_out[7] 0.23139f
C535 a_12790_43377# halfN/xq3.A 0.05812f
C536 a_12499_43487# a_12790_43377# 0.1112f
C537 a_12863_42399# uio_out[2] 0.01401f
C538 VDPWR uio_oe[1] 0.07276f
C539 halfP/xq3.B a_25671_41891# 0.07523f
C540 VDPWR halfP/xq4.X 0.37118f
C541 a_3527_42685# halfN/xq1.A 0.02304f
C542 a_25503_42167# a_24639_42173# 0.03079f
C543 VDPWR halfP/xq2.A 0.7852f
C544 halfN/xq1.A a_4018_42685# 0.01672f
C545 clk a_13427_41597# 0.19377f
C546 halfN/dff1.D a_11318_41897# 0.12611f
C547 a_13337_43633# a_12790_43377# 0.06685f
C548 a_25246_42823# a_25078_43077# 0.16113f
C549 clk halfN/mon.A 0.52083f
C550 a_25246_41053# a_25078_41079# 0.16113f
C551 a_18815_43229# halfP/obuf3.A 0.02626f
C552 a_17930_42141# a_17489_42173# 0.08347f
C553 halfN/xq0.A halfN/xq3.A 1.89169f
C554 a_3527_41597# a_3947_41623# 0.0205f
C555 a_12343_42141# halfN/xq3.A 0.21796f
C556 VDPWR a_15373_42173# 0.26907f
C557 halfP/RDA.R2_8 halfP/RIN.R2_1 0.01627f
C558 a_26119_43255# a_26369_43255# 0.01818f
C559 clk a_12587_42863# 0.01174f
C560 a_12783_43473# a_12403_43487# 0.02545f
C561 halfP/RDA.R2_34 halfP/RDA.R2_32 0.15162f
C562 a_2799_41808# a_2829_41873# 0.01818f
C563 a_13379_42545# a_13250_42289# 0.08347f
C564 clk uio_oe[3] 0.10649f
C565 a_18815_43229# a_18647_43255# 0.20625f
C566 clk a_13434_41897# 0.06509f
C567 a_10843_42399# a_11263_42545# 0.0205f
C568 a_25246_43229# a_25078_43255# 0.16113f
C569 a_12403_43487# VDPWR 0.32134f
C570 halfP/obuf3.A a_17949_43261# 0.05896f
C571 halfN/CM1.C2 halfN/xq5.X 0.01797f
C572 a_17746_41735# a_18003_41989# 0.0205f
C573 a_13243_42385# halfN/dff2.D 0.09341f
C574 a_15630_41735# a_15887_41989# 0.0205f
C575 a_3527_42399# a_3431_42399# 0.20625f
C576 a_16515_42979# VDPWR 0.32306f
C577 a_13243_42385# uio_out[1] 0.01663f
C578 VDPWR uo_out[4] 0.40427f
C579 a_3811_40509# a_3527_40509# 0.03079f
C580 uio_oe[1] halfN/obuf6.A 0.05854f
C581 halfP/xq0.A halfP/xq1.A 0.31342f
C582 uo_out[0] halfP/obuf6.A 0.02465f
C583 clk uio_out[4] 0.3248f
C584 a_4018_40268# a_4365_40369# 0.02068f
C585 VDPWR a_15630_41735# 0.14524f
C586 uio_out[7] halfN/xq2.A 0.03642f
C587 halfN/xq0.B halfN/xq0.X 0.01528f
C588 a_25246_41053# VDPWR 0.14313f
C589 a_18647_43255# a_17949_43261# 0.1112f
C590 a_3464_26480# ua[1] 0.01136f
C591 RT.R1_4 RT.R1_6 0.15162f
C592 a_26369_41079# halfP/xq4.B 0.03769f
C593 halfP/xq2.A a_18171_41891# 0.08716f
C594 a_16531_43255# a_16274_43229# 0.0205f
C595 a_19300_24748# halfP/CM1.C2 2.67812f
C596 a_15833_43261# VDPWR 0.26719f
C597 a_3431_42863# a_3431_43487# 0.01302f
C598 halfP/xq2.X a_26119_42167# 0.11649f
C599 halfP/xq3.X a_26119_41873# 0.1166f
C600 a_15814_42141# a_15207_42173# 0.09081f
C601 halfP/RIN.R2_1 halfP/RDA.R2_10 0.16817f
C602 RT.R1_0 halfP/CM1.C2 0.01305f
C603 a_10383_43487# halfN/obuf5.A 0.01551f
C604 VDPWR ua[0] 2.00916f
C605 halfN/xq2.X halfN/xq5.X 0.10374f
C606 a_6022_24748# ua[1] 0.48222f
C607 VDPWR uio_oe[4] 0.10254f
C608 halfP/xq1.X a_26119_42961# 0.1167f
C609 uo_out[1] a_18187_42167# 0.0241f
C610 halfN/RDA.R2_38 halfN/xq6.X 0.15206f
C611 halfN/dff5.D a_9954_39570# 0.22526f
C612 halfP/mon.A halfP/dff2.D 0.19876f
C613 a_26369_39991# a_26119_39991# 0.01818f
C614 a_25671_41891# a_25671_41053# 0.01257f
C615 a_12959_42399# uio_out[2] 0.01463f
C616 halfP/xq3.A a_24993_41623# 0.08724f
C617 a_10667_43473# halfN/xq2.A 0.04668f
C618 a_24805_43261# halfP/xq0.A 0.17322f
C619 a_12403_43487# halfN/obuf6.A 0.04642f
C620 a_10667_43473# halfN/dff5.D 0.09549f
C621 halfN/xq0.A uio_oe[0] 0.02449f
C622 a_3818_41201# VDPWR 0.25972f
C623 halfN/RIN.R2_1 halfN/xq5.X 0.24612f
C624 a_25503_43255# halfP/xq0.A 0.02268f
C625 ui_in[1] ui_in[0] 0.01551f
C626 a_16274_43229# a_16106_43255# 0.16113f
C627 VDPWR a_13427_41597# 0.52639f
C628 a_2799_42141# VDPWR 0.14245f
C629 a_2799_42896# halfN/xq1.B 0.22941f
C630 a_2799_41808# halfN/xq3.A 0.07434f
C631 VDPWR halfN/mon.A 0.72577f
C632 uo_out[1] a_17783_43261# 0.01898f
C633 a_10674_43377# a_10383_43487# 0.1112f
C634 RT.R1_2 RT.R1_4 0.15162f
C635 halfN/obuf3.A a_3527_40509# 0.02208f
C636 halfN/dff1.D a_9954_39096# 0.09435f
C637 VDPWR a_12587_42863# 0.32306f
C638 a_24639_43261# a_25078_43255# 0.16041f
C639 a_24805_41085# a_25078_41079# 0.07623f
C640 a_25246_41735# halfP/xq3.A 0.01986f
C641 a_26119_39991# halfP/obuf5.A 0.07434f
C642 halfP/xq5.X halfP/xq5.B 0.01329f
C643 VDPWR a_3431_41775# 0.31659f
C644 VDPWR uio_oe[3] 0.07069f
C645 a_24805_42173# a_24639_42173# 0.56916f
C646 VDPWR a_3527_41311# 0.15812f
C647 halfP/obuf5.A a_24805_39997# 0.17203f
C648 a_4018_41597# a_4365_41623# 0.02068f
C649 VDPWR a_13434_41897# 0.26564f
C650 clk uio_oe[2] 0.08513f
C651 halfN/RDA.R1_25 halfN/RDA.R1_27 0.15162f
C652 uio_out[7] halfN/obuf5.A 0.14229f
C653 a_10667_43473# uio_out[5] 0.01117f
C654 a_24639_42173# a_24639_42711# 0.02056f
C655 halfP/xq5.B halfP/xq6.B 0.01239f
C656 a_24805_40535# a_25671_40803# 0.01914f
C657 a_17578_41989# a_17305_41623# 0.07623f
C658 VDPWR a_4365_42545# 0.05353f
C659 RBT.R1_6 ua[1] 0.01193f
C660 a_15649_42711# halfP/xq0.A 0.06022f
C661 halfN/RDA.R2_32 halfN/xq5.X 0.15209f
C662 a_13427_41597# a_13634_41597# 0.16041f
C663 a_3818_43377# a_3431_43487# 0.01914f
C664 halfP/RDA.R1_37 halfP/RDA.R1_35 0.15162f
C665 halfP/xq3.A a_24805_42173# 0.01037f
C666 VDPWR uio_out[4] 0.36162f
C667 a_3818_41201# halfN/obuf6.A 0.17223f
C668 halfP/obuf5.A a_25671_39965# 0.02906f
C669 VDPWR a_3947_40535# 0.14313f
C670 halfP/RIN.R2_1 halfP/xq0.X 0.9475f
C671 a_3818_41201# a_3818_40809# 0.01371f
C672 halfP/RDA.R2_26 halfP/xq4.X 0.15213f
C673 a_2829_42961# halfN/xq1.B 0.03769f
C674 VDPWR a_25246_42823# 0.14313f
C675 a_11311_41597# halfN/dff3.D 0.07007f
C676 a_3527_41597# halfN/xq3.A 0.02222f
C677 halfN/xq5.X halfN/xq4.X 3.6208f
C678 clk a_13243_42385# 0.19991f
C679 uio_out[6] halfN/xq1.A 0.02978f
C680 RB.R2_1 a_3464_26480# 0.42712f
C681 a_13434_41897# a_13634_41597# 0.07623f
C682 a_12790_43377# a_12919_43633# 0.08347f
C683 a_15786_39096# halfP/dff3.D 0.08266f
C684 VDPWR a_24805_41085# 0.25972f
C685 uio_in[0] ui_in[7] 0.01551f
C686 VDPWR a_18137_43255# 0.05353f
C687 a_25246_40647# a_24639_40535# 0.09081f
C688 halfP/dff4.D a_16090_42823# 0.01017f
C689 a_12587_42863# halfN/obuf6.A 0.08626f
C690 a_4018_43532# a_3818_43377# 0.07623f
C691 halfN/xq6.B a_2799_39965# 0.22941f
C692 VDPWR a_26119_41873# 0.14245f
C693 RB.R2_1 a_6022_24748# 0.0467f
C694 halfP/xq5.X halfP/xq0.X 0.12005f
C695 VDPWR a_3185_43255# 0.01434f
C696 VDPWR a_26369_42961# 0.16163f
C697 a_24639_42173# a_25246_42141# 0.09081f
C698 halfN/obuf6.A a_3527_41311# 0.02208f
C699 halfP/RDA.R2_34 halfP/RIN.R2_1 0.16817f
C700 halfP/dff4.D halfP/dff5.D 0.11246f
C701 halfN/xq0.A a_12919_43633# 0.02654f
C702 uio_oe[5] tie_oe5.LO 0.04431f
C703 a_16699_43229# halfP/xq1.A 0.09377f
C704 halfP/xq3.B a_26369_41873# 0.03769f
C705 halfP/obuf3.A a_26119_40785# 0.07434f
C706 a_3811_41297# a_4365_41457# 0.04548f
C707 halfP/xq2.X halfP/RIN.R2_1 0.24759f
C708 halfP/mon.A a_15207_42173# 0.01252f
C709 a_3818_41897# a_3947_41623# 0.08347f
C710 halfN/RDA.R2_4 halfN/RIN.R2_1 0.16817f
C711 uo_out[6] halfP/dff6.D 0.09162f
C712 a_24805_41623# a_25078_41989# 0.07623f
C713 a_2799_42141# halfN/xq2.B 0.22941f
C714 halfP/RDA.R1_19 halfP/RDA.R1_21 0.15162f
C715 a_10667_43473# a_10674_43377# 0.56916f
C716 uio_out[4] halfN/obuf6.A 0.03518f
C717 VDPWR a_4018_40509# 0.19701f
C718 uo_out[5] a_15207_42173# 0.01382f
C719 uio_out[6] halfN/xq3.A 0.01828f
C720 halfP/dff1.D a_17305_41623# 0.12611f
C721 halfP/xq2.X halfP/xq5.X 0.10374f
C722 a_3947_40535# a_3818_40809# 0.08347f
C723 a_3811_43473# a_3431_43487# 0.02545f
C724 uio_out[5] uio_out[2] 0.0306f
C725 a_3527_43487# halfN/xq0.A 0.02268f
C726 VDPWR a_17026_24748# 0.06927f
C727 a_24993_43255# halfP/xq0.A 0.08753f
C728 VDPWR a_4365_41623# 0.05353f
C729 halfP/xq1.B a_26369_42961# 0.03769f
C730 VDPWR uio_oe[2] 0.10252f
C731 halfN/xq3.X halfN/xq6.X 0.10727f
C732 halfN/CM1.C2 ua[1] 1.18821f
C733 a_12863_42399# halfN/xq3.A 0.09349f
C734 a_10667_43473# a_10874_43532# 0.16041f
C735 halfN/RDA.R2_26 halfN/RDA.R2_28 0.15162f
C736 uio_out[3] halfN/xq0.A 0.04343f
C737 halfP/dff4.D halfP/dff6.D 0.3279f
C738 halfN/dff2.D a_9954_39570# 0.13052f
C739 a_19255_43255# halfP/obuf5.A 0.23309f
C740 a_4365_42711# halfN/xq1.A 0.08767f
C741 a_25503_42167# a_25671_42141# 0.20625f
C742 a_3527_43487# a_3947_43633# 0.0205f
C743 a_3811_43473# a_4018_43532# 0.16041f
C744 VDPWR halfN/xq6.X 0.7839f
C745 uo_out[7] uio_out[0] 0.18612f
C746 halfN/mon.A a_9954_39096# 0.10733f
C747 a_3811_40209# halfN/obuf5.A 0.09393f
C748 a_15922_43077# a_15483_42711# 0.16041f
C749 VDPWR halfP/xq0.B 0.22607f
C750 clk a_16090_42823# 0.01279f
C751 halfP/xq2.B a_26119_42167# 0.22941f
C752 a_25078_40901# a_25246_40647# 0.16113f
C753 uo_out[5] a_15649_42711# 0.01178f
C754 VDPWR a_13243_42385# 0.52614f
C755 a_3811_42385# halfN/xq3.A 0.01412f
C756 a_13337_43633# a_12990_43532# 0.02068f
C757 a_17762_42167# a_17489_42173# 0.07623f
C758 halfN/xq2.X ua[1] 0.03655f
C759 a_15306_39570# halfP/dff3.D 0.11567f
C760 clk halfP/dff5.D 0.02239f
C761 a_25671_43229# a_24639_43261# 0.02545f
C762 a_2829_40785# a_2799_40720# 0.01818f
C763 a_4365_43633# a_4018_43532# 0.02068f
C764 a_4018_40509# a_3818_40809# 0.07623f
C765 a_25671_42979# halfP/xq1.A 0.03011f
C766 VDPWR a_4018_40268# 0.19596f
C767 a_25246_41053# a_24639_41085# 0.09081f
C768 RBT.R1_2 halfP/CM1.C2 0.01305f
C769 a_16699_43229# halfP/obuf6.A 0.04642f
C770 uo_out[2] halfP/dff5.D 0.20942f
C771 uio_oe[6] halfN/xq0.A 0.02604f
C772 a_16021_43255# a_15667_43261# 0.04548f
C773 RBT.R1_2 RBT.R1_0 0.15162f
C774 a_13174_42685# a_13521_42711# 0.02068f
C775 halfP/RDA.R2_40 halfP/RIN.R2_1 0.16817f
C776 halfP/obuf3.A a_24639_40535# 0.09534f
C777 a_3431_41311# VDPWR 0.31659f
C778 a_18390_43229# a_17783_43261# 0.09081f
C779 uio_oe[2] halfN/obuf6.A 0.03955f
C780 RARR.R1_3 a_15306_39570# 0.04725f
C781 halfN/RIN.R2_1 ua[1] 0.34505f
C782 a_24805_41623# a_24639_41623# 0.56916f
C783 VDPWR a_26201_41873# 0.01434f
C784 a_11311_41597# a_11447_41623# 0.09081f
C785 a_3527_42399# a_3947_42545# 0.0205f
C786 a_19300_24748# halfP/RIN.R2_1 0.0799f
C787 a_24805_42711# a_25671_42979# 0.01914f
C788 halfP/xq0.B halfP/xq1.B 0.01221f
C789 clk a_13450_42444# 0.01016f
C790 halfN/RDA.R2_14 halfN/xq2.X 0.15227f
C791 a_10803_43633# halfN/xq2.A 0.02793f
C792 a_26119_40785# halfP/xq5.B 0.22941f
C793 VDPWR a_18355_42141# 0.32214f
C794 halfP/xq0.A a_24639_42711# 0.01017f
C795 a_18355_42141# a_17323_42173# 0.02545f
C796 RT.R1_0 ua[1] 0.01193f
C797 halfP/dff4.D a_15189_41623# 0.05852f
C798 clk halfP/dff6.D 0.24174f
C799 ua[0] halfP/xq4.X 0.05501f
C800 halfP/xq2.B a_25671_42141# 0.07523f
C801 uio_out[6] halfN/obuf3.A 0.12158f
C802 VDPWR a_3818_42289# 0.25972f
C803 a_19300_24748# halfP/xq5.X 0.025f
C804 halfN/RDA.R2_14 halfN/RIN.R2_1 0.01627f
C805 a_5356_24748# a_3464_26480# 0.02508f
C806 a_2829_40785# halfN/xq5.X 0.05741f
C807 uio_oe[5] halfN/xq0.A 0.0197f
C808 VDPWR a_26201_41079# 0.01434f
C809 uio_in[3] uio_in[4] 0.01551f
C810 uo_out[6] a_15023_41623# 0.02991f
C811 halfN/dff5.D a_9894_39596# 0.01435f
C812 uo_out[1] halfP/obuf3.A 0.12158f
C813 RB.R2_1 halfN/CM1.C2 2.96222f
C814 a_5356_24748# a_6022_24748# 0.70727f
C815 a_3431_41311# halfN/obuf6.A 0.02906f
C816 a_3818_41897# halfN/xq3.A 0.17417f
C817 clk uio_out[7] 0.09305f
C818 a_3811_40209# a_4365_40369# 0.04548f
C819 RT.R1_4 halfP/CM1.C2 0.01305f
C820 a_3947_40369# a_3818_40113# 0.08347f
C821 a_16531_43255# halfP/obuf6.A 0.02142f
C822 a_16515_42979# uo_out[4] 0.02178f
C823 a_12967_42685# a_13174_42685# 0.16041f
C824 uio_out[1] uio_out[2] 0.42206f
C825 halfN/xq4.X ua[1] 0.05501f
C826 halfN/xq3.X halfN/xq1.X 0.10651f
C827 halfN/dff2.D a_13797_42545# 0.0852f
C828 a_15646_42167# a_15561_42167# 0.02068f
C829 VDPWR a_16090_42823# 0.14519f
C830 a_13243_42385# a_13250_42289# 0.56916f
C831 RBT.R1_6 rst_n 0.0508f
C832 irst.Y a_3464_26480# 0.07869f
C833 a_2829_41873# halfN/xq3.B 0.03769f
C834 halfP/xq0.B a_26369_43255# 0.03769f
C835 halfN/dff4.D a_12294_39596# 0.01219f
C836 halfP/xq3.A a_25503_41989# 0.02222f
C837 a_10843_42399# VDPWR 0.16327f
C838 halfN/xq1.A halfN/xq2.A 1.71331f
C839 VDPWR halfP/dff5.D 0.9079f
C840 halfP/xq3.A a_16679_42167# 0.21796f
C841 a_17323_42173# halfP/dff5.D 0.04714f
C842 halfP/obuf3.A a_25078_40901# 0.01515f
C843 a_10747_42399# halfN/obuf3.A 0.09379f
C844 a_11127_42385# halfN/dff3.D 0.09566f
C845 halfN/RDA.R1_7 halfN/RDA.R1_5 0.15162f
C846 a_24993_42167# a_25078_42167# 0.02068f
C847 uio_oe[1] uio_oe[3] 0.03476f
C848 irst.Y a_6022_24748# 0.04337f
C849 clk a_10667_43473# 0.164f
C850 halfP/dff4.D a_15023_41623# 0.01863f
C851 VDPWR halfN/xq1.X 0.33228f
C852 a_25671_42141# a_24805_42173# 0.01914f
C853 a_26369_40785# halfP/xq5.B 0.03769f
C854 a_24805_43261# a_25078_43255# 0.07623f
C855 VDPWR a_10383_43487# 0.1567f
C856 rst_n halfP/xq0.X 0.01872f
C857 halfP/RDA.R2_4 halfP/RDA.R2_2 0.15162f
C858 clk a_24639_42173# 0.15601f
C859 halfP/RIN.R2_1 halfP/RDA.R2_2 0.01627f
C860 a_15786_39096# halfP/dff2.D 0.09222f
C861 a_24805_41085# a_24639_41085# 0.56916f
C862 a_3431_42863# halfN/xq1.A 0.03011f
C863 halfN/RDA.R2_14 halfN/RDA.R2_16 0.15162f
C864 halfN/dff5.D a_11311_41597# 0.02396f
C865 a_12967_42685# uio_out[2] 0.0115f
C866 RB.R2_1 halfN/RIN.R2_1 1.24011f
C867 halfN/RDA.R1_0 halfN/RDA.R1_1 0.15162f
C868 a_11127_42385# uio_out[6] 0.01286f
C869 a_15483_42711# a_15837_42711# 0.04548f
C870 VDPWR a_26201_40785# 0.01434f
C871 halfP/xq3.X halfP/xq1.X 0.10651f
C872 clk a_15189_41623# 0.06509f
C873 VDPWR a_13450_42444# 0.19716f
C874 clk halfP/xq3.A 0.7499f
C875 a_18222_43255# a_17783_43261# 0.16041f
C876 uio_out[5] halfN/xq1.A 0.0315f
C877 halfN/xq0.X halfN/xq6.X 0.12351f
C878 uio_oe[7] halfN/xq1.A 0.0401f
C879 RB.R2_1 a_19300_24748# 0.0467f
C880 uo_out[2] halfP/xq3.A 0.02232f
C881 halfP/xq1.X halfP/xq6.X 0.10624f
C882 a_17677_42167# a_17489_42173# 0.06685f
C883 halfN/xq2.A halfN/xq3.A 0.53275f
C884 VDPWR halfP/dff6.D 0.55986f
C885 halfP/xq2.X rst_n 0.03421f
C886 RBT.R2_0 a_17026_24748# 4.51516f
C887 a_26119_43255# halfP/xq0.B 0.22941f
C888 a_12990_43532# a_12919_43633# 0.16113f
C889 a_10803_43633# a_10674_43377# 0.08347f
C890 clk a_13174_42685# 0.01273f
C891 halfP/dff5.D a_18171_41891# 0.028f
C892 VDPWR a_3431_43487# 0.31647f
C893 a_10287_43487# halfN/obuf3.A 0.02626f
C894 a_3431_40223# a_3431_40687# 0.01257f
C895 a_11311_41597# uio_out[5] 0.0293f
C896 halfP/dff1.D a_15786_39096# 0.09435f
C897 VDPWR a_25671_40803# 0.31659f
C898 a_18222_43255# a_18390_43229# 0.16113f
C899 a_11127_42385# a_10747_42399# 0.02545f
C900 VDPWR uio_out[7] 0.40434f
C901 VDPWR a_26369_41079# 0.16163f
C902 uo_out[6] halfP/xq0.A 0.1014f
C903 clk a_17139_41623# 0.16736f
C904 halfN/xq3.B halfN/xq3.A 0.20854f
C905 tie_oe0.LO uio_oe[0] 0.056f
C906 a_13379_42545# a_13243_42385# 0.09081f
C907 uio_out[6] a_10227_42141# 0.23093f
C908 halfN/xq5.B a_2799_40720# 0.22941f
C909 uo_out[2] a_17139_41623# 0.0293f
C910 a_10803_43633# a_10874_43532# 0.16113f
C911 a_25503_40901# a_24639_40535# 0.03079f
C912 uio_oe[4] uio_oe[3] 0.32324f
C913 a_11127_42385# a_11134_42289# 0.56916f
C914 halfN/obuf5.A a_3431_40223# 0.02906f
C915 RBT.R1_6 RBT.R1_4 0.15162f
C916 clk a_15023_41623# 0.19377f
C917 halfP/dff4.D a_15814_42141# 0.0255f
C918 VDPWR a_9954_39570# 4.23244f
C919 VDPWR a_4018_43532# 0.19701f
C920 halfP/CM1.C2 halfP/xq6.X 0.0215f
C921 uio_out[5] halfN/xq3.A 0.02232f
C922 a_2829_39991# halfN/xq6.X 0.0574f
C923 uio_oe[7] halfN/xq3.A 0.02824f
C924 clk a_3811_40209# 0.15451f
C925 halfN/mon.A a_13427_41597# 0.06481f
C926 clk uio_out[2] 0.64325f
C927 a_11518_41597# halfN/dff3.D 0.0268f
C928 uio_oe[0] tie_oe1.LO 0.01546f
C929 a_3818_43377# halfN/xq1.A 0.01279f
C930 a_15667_43261# a_16274_43229# 0.09081f
C931 VDPWR a_10667_43473# 0.51616f
C932 a_3818_41201# a_3527_41311# 0.1112f
C933 clk uo_out[0] 0.09524f
C934 uio_oe[1] uio_oe[2] 0.47355f
C935 uo_out[6] a_16055_41891# 0.01528f
C936 a_25246_41053# a_24805_41085# 0.08347f
C937 clk a_11883_43229# 0.03997f
C938 halfP/dff4.D halfP/xq0.A 0.09501f
C939 a_15306_39570# halfP/dff2.D 0.13052f
C940 a_12974_42985# a_13521_42711# 0.06685f
C941 VDPWR a_24639_42173# 0.5153f
C942 a_13434_41897# a_13427_41597# 0.56916f
C943 halfP/obuf3.A a_17783_43261# 0.01871f
C944 halfN/RDA.R1_23 halfN/RDA.R1_21 0.15162f
C945 halfN/mon.A a_13434_41897# 0.13009f
C946 a_15189_41623# a_15887_41989# 0.1112f
C947 a_16239_42141# a_16071_42167# 0.20625f
C948 a_13143_41597# a_13563_41623# 0.0205f
C949 a_13563_41623# halfN/dff6.D 0.02746f
C950 ui_in[3] ui_in[2] 0.01551f
C951 a_13250_42289# a_13450_42444# 0.07623f
C952 a_17746_41735# halfP/dff5.D 0.01531f
C953 VDPWR a_15189_41623# 0.26564f
C954 uio_oe[0] halfN/xq2.A 0.06455f
C955 a_5356_24748# halfN/CM1.C2 1.28418f
C956 uio_out[7] halfN/obuf6.A 0.02006f
C957 a_18647_43255# a_17783_43261# 0.03079f
C958 VDPWR halfP/xq3.A 0.74936f
C959 a_3527_42685# a_3818_42985# 0.1112f
C960 halfN/xq5.B halfN/xq5.X 0.01329f
C961 a_3811_40509# a_3431_40687# 0.02545f
C962 a_3818_42985# a_4018_42685# 0.07623f
C963 halfP/RDA.R1_17 halfP/RDA.R1_19 0.15162f
C964 VDPWR halfP/xq1.X 0.31489f
C965 a_26201_42961# VDPWR 0.01434f
C966 a_24993_43255# a_25078_43255# 0.02068f
C967 halfP/dff4.D a_16055_41891# 0.01711f
C968 RBT.R1_2 ua[1] 0.01193f
C969 VDPWR a_13174_42685# 0.20115f
C970 halfN/dff4.D a_13563_41623# 0.01026f
C971 halfN/dff4.D a_13143_41597# 0.02619f
C972 halfN/dff4.D halfN/dff6.D 0.3279f
C973 halfN/obuf3.A halfN/xq2.A 1.29772f
C974 halfP/RDA.R2_38 halfP/RIN.R2_1 0.01627f
C975 a_24805_43261# a_25671_43229# 0.01914f
C976 halfP/obuf3.A halfP/obuf5.A 1.90494f
C977 a_18003_41989# halfP/dff5.D 0.03402f
C978 halfP/dff1.D a_15306_39570# 0.1291f
C979 a_11311_41597# a_11027_41597# 0.03079f
C980 a_18390_43229# a_18647_43255# 0.0205f
C981 irst.Y halfN/CM1.C2 2.57431f
C982 a_25671_42979# a_24639_42711# 0.02545f
C983 halfN/xq0.X halfN/xq1.X 4.58764f
C984 VDPWR a_3185_42167# 0.01434f
C985 a_15646_42167# a_15207_42173# 0.16041f
C986 RT.R1_0 rst_n 0.05196f
C987 a_25503_43255# a_25671_43229# 0.20625f
C988 a_3527_42399# a_3811_42385# 0.03079f
C989 clk a_15814_42141# 0.01392f
C990 uo_out[1] halfP/xq1.A 0.02978f
C991 ui_in[0] rst_n 0.01551f
C992 VDPWR a_17139_41623# 0.52712f
C993 a_3527_40223# halfN/obuf5.A 0.02208f
C994 uo_out[6] halfP/mon.A 0.01038f
C995 a_3811_43473# halfN/xq1.A 0.01756f
C996 a_18647_43255# halfP/obuf5.A 0.01551f
C997 a_15023_41623# a_15887_41989# 0.03079f
C998 a_13047_41775# a_13143_41597# 0.20625f
C999 a_12783_43473# uio_out[2] 0.01534f
C1000 a_12974_42985# a_12967_42685# 0.56916f
C1001 VDPWR a_2799_40720# 0.14245f
C1002 a_5356_24748# halfN/RIN.R2_1 4.86621f
C1003 uo_out[3] halfP/xq1.A 0.0989f
C1004 VDPWR a_15023_41623# 0.52639f
C1005 uio_oe[4] uio_oe[2] 0.1262f
C1006 a_4018_41597# a_3947_41623# 0.16113f
C1007 VDPWR halfP/CM1.C2 2.15886f
C1008 a_3811_41297# a_3947_41457# 0.09081f
C1009 halfP/xq1.X halfP/xq1.B 0.01333f
C1010 halfN/xq0.A a_12527_41597# 0.20393f
C1011 uo_out[6] uo_out[5] 0.42206f
C1012 clk halfP/xq0.A 1.00108f
C1013 a_3811_41297# a_4018_41356# 0.16041f
C1014 VDPWR a_3811_40209# 0.51401f
C1015 tie_oe6.LO uio_oe[6] 0.04907f
C1016 VDPWR uio_out[2] 0.4492f
C1017 a_18355_42141# halfP/xq2.A 0.04503f
C1018 a_10411_41597# halfN/xq2.A 0.20393f
C1019 RB.R2_1 a_5130_26120# 0.11661f
C1020 halfP/RDA.R1_15 halfP/RDA.R1_17 0.15162f
C1021 uio_oe[7] halfN/obuf3.A 0.03026f
C1022 halfP/obuf6.A a_24639_40535# 0.01017f
C1023 uo_out[2] halfP/xq0.A 0.02211f
C1024 VDPWR a_13797_42545# 0.05353f
C1025 a_10411_41597# halfN/dff5.D 0.01898f
C1026 uio_oe[0] halfN/obuf5.A 0.03741f
C1027 halfN/obuf3.A a_3431_40687# 0.02906f
C1028 VDPWR uo_out[0] 0.40234f
C1029 halfN/xq0.B a_3431_43487# 0.07523f
C1030 a_18187_42167# a_17930_42141# 0.0205f
C1031 a_25246_43229# a_24639_43261# 0.09081f
C1032 VDPWR a_11883_43229# 0.32344f
C1033 halfN/RDA.R2_20 halfN/RIN.R2_1 0.01627f
C1034 halfN/dff4.D a_13047_41775# 0.01711f
C1035 a_13379_42545# a_13450_42444# 0.16113f
C1036 halfP/dff4.D halfP/mon.A 0.41201f
C1037 irst.Y halfN/RIN.R2_1 0.6527f
C1038 RT.R1_4 ua[1] 0.01193f
C1039 halfN/xq3.X halfN/xq5.X 0.1062f
C1040 clk a_17489_42173# 0.01723f
C1041 a_11518_41597# a_11447_41623# 0.16113f
C1042 a_15483_42711# a_15649_42711# 0.56916f
C1043 clk a_16055_41891# 0.02344f
C1044 a_2829_42961# a_2799_42896# 0.01818f
C1045 a_17139_41623# a_18171_41891# 0.02545f
C1046 halfN/obuf3.A halfN/obuf5.A 1.90494f
C1047 a_9954_39096# a_9954_39570# 0.12634f
C1048 uo_out[2] a_17489_42173# 0.02549f
C1049 a_11127_42385# halfN/dff5.D 0.04714f
C1050 halfP/obuf3.A a_25246_40647# 0.01931f
C1051 halfP/dff4.D uo_out[5] 0.05796f
C1052 a_19300_24748# irst.Y 0.04337f
C1053 uio_oe[3] uio_oe[2] 0.40516f
C1054 a_10411_41597# uio_out[5] 0.22579f
C1055 a_24993_39991# a_25078_39991# 0.02068f
C1056 VDPWR halfN/xq5.X 0.43323f
C1057 halfP/obuf6.A a_26119_41079# 0.07434f
C1058 clk a_3811_41297# 0.15601f
C1059 a_3947_40535# a_4018_40509# 0.16113f
C1060 halfP/xq2.A halfP/dff5.D 0.10293f
C1061 halfN/mon.A a_13243_42385# 0.01252f
C1062 clk a_12974_42985# 0.03697f
C1063 halfP/mon.A a_14839_42711# 0.16227f
C1064 uo_out[1] halfP/obuf6.A 0.01867f
C1065 a_11311_41597# a_11865_41623# 0.04548f
C1066 halfP/RDA.R1_25 halfP/RDA.R1_23 0.15162f
C1067 a_3818_41201# a_3431_41311# 0.01914f
C1068 a_15649_42711# a_16347_43077# 0.1112f
C1069 halfN/dff4.D a_12790_43377# 0.16439f
C1070 a_3431_42863# halfN/xq1.B 0.07523f
C1071 VDPWR a_15814_42141# 0.14866f
C1072 a_11127_42385# uio_out[5] 0.02827f
C1073 uo_out[3] halfP/obuf6.A 0.03518f
C1074 a_10674_43377# halfN/obuf3.A 0.05896f
C1075 uo_out[5] a_16679_42167# 0.21743f
C1076 a_19006_39596# halfP/dff3.D 0.01167f
C1077 a_11127_42385# a_11263_42545# 0.09081f
C1078 clk halfN/xq1.A 0.41123f
C1079 halfN/xq0.A halfN/dff4.D 0.09501f
C1080 a_11127_42385# a_11681_42545# 0.04548f
C1081 tie_oe4.LO VDPWR 0.29822f
C1082 VDPWR a_3947_41623# 0.14313f
C1083 a_13250_42289# uio_out[2] 0.0162f
C1084 a_3431_41311# a_3431_41775# 0.01257f
C1085 VDPWR halfP/xq0.A 0.74457f
C1086 a_3431_41311# a_3527_41311# 0.20625f
C1087 clk halfP/mon.A 0.52083f
C1088 VDPWR a_26119_42167# 0.14245f
C1089 a_13250_42289# a_13797_42545# 0.06685f
C1090 halfN/RDA.R2_34 halfN/RIN.R2_1 0.16817f
C1091 a_24993_41623# a_25078_41989# 0.02068f
C1092 a_11334_42444# a_11134_42289# 0.07623f
C1093 clk a_11311_41597# 0.16736f
C1094 a_17746_41735# a_17139_41623# 0.09081f
C1095 halfN/RDA.R2_4 halfN/RDA.R2_2 0.15162f
C1096 halfN/xq0.A a_13047_41775# 0.08716f
C1097 halfP/xq3.X halfP/RIN.R2_1 0.24673f
C1098 uio_in[6] uio_in[7] 0.01551f
C1099 uo_out[6] a_16495_41623# 0.2142f
C1100 a_25503_41989# a_25671_41891# 0.20625f
C1101 clk uo_out[5] 0.64325f
C1102 halfN/dff1.D a_9954_39570# 0.1291f
C1103 a_26201_42167# VDPWR 0.01434f
C1104 uio_out[3] uio_out[5] 0.023f
C1105 a_15373_42173# halfP/dff6.D 0.04636f
C1106 a_16055_41891# a_15887_41989# 0.20625f
C1107 RT.R2_1 RT.R2_3 0.15162f
C1108 VDPWR a_10803_43633# 0.14346f
C1109 a_26369_41079# halfP/xq4.X 0.05742f
C1110 a_17139_41623# a_17493_41623# 0.04548f
C1111 halfN/RDA.R1_31 halfN/RDA.R1_29 0.15162f
C1112 VDPWR a_17489_42173# 0.26898f
C1113 a_3527_42399# halfN/xq2.A 0.02237f
C1114 uo_out[2] uo_out[5] 0.0306f
C1115 a_17323_42173# a_17489_42173# 0.56916f
C1116 halfP/obuf5.A halfP/xq0.X 0.01069f
C1117 clk a_16699_43229# 0.02065f
C1118 halfP/RIN.R2_1 halfP/xq6.X 0.246f
C1119 VDPWR a_16055_41891# 0.32259f
C1120 a_26369_42167# a_26119_42167# 0.01818f
C1121 halfN/xq3.X a_2829_41873# 0.05743f
C1122 a_4018_41597# halfN/xq3.A 0.01601f
C1123 a_18003_41989# a_17139_41623# 0.03079f
C1124 clk a_12499_43487# 0.01831f
C1125 clk halfN/xq3.A 0.7139f
C1126 halfP/xq3.X halfP/xq5.X 0.1062f
C1127 a_17578_41989# halfP/dff3.D 0.0268f
C1128 a_25246_41735# a_25078_41989# 0.16113f
C1129 a_25503_43077# halfP/xq1.A 0.02304f
C1130 a_3818_42289# a_4365_42545# 0.06685f
C1131 a_12683_42685# halfN/xq0.A 0.02106f
C1132 VDPWR a_18795_42167# 0.32602f
C1133 halfN/RDA.R2_32 halfN/RDA.R2_34 0.15162f
C1134 a_3811_41297# VDPWR 0.5153f
C1135 VDPWR a_2829_41873# 0.16163f
C1136 a_12974_42985# VDPWR 0.26655f
C1137 a_25503_41079# a_25671_41053# 0.20625f
C1138 halfP/xq5.X halfP/xq6.X 3.26485f
C1139 a_24993_42711# halfP/xq1.A 0.08767f
C1140 a_15630_41735# halfP/dff6.D 0.02746f
C1141 a_2829_42167# halfN/xq2.X 0.05746f
C1142 halfN/xq0.A a_12790_43377# 0.04327f
C1143 a_5356_24748# a_5130_26120# 0.06359f
C1144 uio_oe[6] uio_oe[7] 0.41893f
C1145 a_18647_43255# halfP/obuf3.A 0.03163f
C1146 ui_in[5] ui_in[4] 0.01551f
C1147 VDPWR a_25671_42141# 0.31659f
C1148 a_18611_41623# uo_out[2] 0.22579f
C1149 halfP/RDA.R1_29 halfP/RDA.R1_27 0.15162f
C1150 a_13103_42711# a_13174_42685# 0.16113f
C1151 halfP/xq6.B halfP/xq6.X 0.01329f
C1152 a_3527_43487# a_3818_43377# 0.1112f
C1153 a_11518_41597# uio_out[5] 0.01256f
C1154 a_3811_41597# a_3527_41597# 0.03079f
C1155 a_3811_42685# halfN/xq1.A 0.10013f
C1156 a_24639_42173# halfP/xq2.A 0.09482f
C1157 a_25503_43077# a_24805_42711# 0.1112f
C1158 a_15922_43077# a_15837_42711# 0.02068f
C1159 RBT.R1_2 rst_n 0.04565f
C1160 halfN/obuf5.A a_2799_39965# 0.07434f
C1161 clk a_3811_40509# 0.15601f
C1162 clk a_17949_43261# 0.01782f
C1163 a_24805_42711# a_24993_42711# 0.06685f
C1164 a_3818_42985# a_4365_42711# 0.06685f
C1165 VDPWR halfN/xq1.A 0.61567f
C1166 a_3811_42385# a_3431_42399# 0.02545f
C1167 RBT.R2_0 halfP/CM1.C2 1.53866f
C1168 a_24993_39991# a_24805_39997# 0.06685f
C1169 clk a_17305_41623# 0.02201f
C1170 a_26119_41079# halfP/xq4.B 0.22941f
C1171 halfP/xq3.A halfP/xq2.A 0.53275f
C1172 uio_oe[6] halfN/obuf5.A 0.0136f
C1173 a_24639_41623# a_24993_41623# 0.04548f
C1174 halfP/xq1.X halfP/xq4.X 0.1039f
C1175 VDPWR halfP/mon.A 0.72577f
C1176 uo_out[2] a_17305_41623# 0.01277f
C1177 VDPWR a_3431_40223# 0.31612f
C1178 halfN/xq0.X halfN/xq5.X 0.12005f
C1179 clk a_16531_43255# 0.01831f
C1180 VDPWR a_11311_41597# 0.52712f
C1181 halfN/xq0.A a_3947_43633# 0.02002f
C1182 a_25503_40901# a_25246_40647# 0.0205f
C1183 halfP/RDA.R2_14 halfP/RDA.R2_16 0.15162f
C1184 a_3811_41297# halfN/obuf6.A 0.09427f
C1185 halfN/RDA.R2_10 halfN/RIN.R2_1 0.16817f
C1186 a_25503_39991# a_24805_39997# 0.1112f
C1187 uio_oe[5] uio_oe[7] 0.04727f
C1188 halfN/xq3.X ua[1] 0.04014f
C1189 VDPWR uo_out[5] 0.4492f
C1190 halfP/dff1.D a_17566_39596# 0.01201f
C1191 clk uio_oe[0] 0.07448f
C1192 a_17323_42173# uo_out[5] 0.01003f
C1193 a_12499_43487# a_12783_43473# 0.03079f
C1194 a_12783_43473# halfN/xq3.A 0.01805f
C1195 halfP/dff1.D halfP/dff3.D 0.09513f
C1196 halfP/dff5.D a_18137_43255# 0.0852f
C1197 RARR.R1_3 RARR.R1_1 0.03095f
C1198 VDPWR halfP/RIN.R2_1 0.85961f
C1199 VDPWR a_16699_43229# 0.32134f
C1200 a_15207_42173# a_16071_42167# 0.03079f
C1201 a_24805_40535# a_24639_40535# 0.56916f
C1202 halfN/dff3.D halfN/dff6.D 0.49963f
C1203 VDPWR tie_oe2.LO 0.29824f
C1204 a_25246_41735# a_24639_41623# 0.09081f
C1205 a_11318_41897# a_11311_41597# 0.56916f
C1206 a_16515_42979# halfP/xq3.A 0.03559f
C1207 a_10931_41775# halfN/xq2.A 0.08716f
C1208 VDPWR ua[1] 1.47304f
C1209 a_15630_41735# a_15189_41623# 0.08347f
C1210 a_12499_43487# VDPWR 0.16201f
C1211 RBT.R2_0 RBT.R2_1 0.1593f
C1212 VDPWR halfN/xq3.A 0.74776f
C1213 a_12783_43473# a_13337_43633# 0.04548f
C1214 a_25503_39991# a_25671_39965# 0.20625f
C1215 uo_out[4] halfP/xq3.A 0.11342f
C1216 clk a_16495_41623# 0.03615f
C1217 a_3811_43473# a_3527_43487# 0.03079f
C1218 halfP/CM1.C2 halfP/xq4.X 0.01715f
C1219 halfN/xq1.A halfN/obuf6.A 1.60219f
C1220 clk a_12067_42685# 0.01814f
C1221 halfN/obuf3.A halfN/xq5.B 0.20854f
C1222 uio_oe[5] halfN/obuf5.A 0.02613f
C1223 a_10931_41775# halfN/dff5.D 0.028f
C1224 RT.R1_4 rst_n 0.04565f
C1225 a_15377_41623# halfP/dff2.D 0.01238f
C1226 clk halfN/obuf3.A 0.60293f
C1227 clk a_16106_43255# 0.01491f
C1228 a_15833_43261# halfP/xq3.A 0.05812f
C1229 VDPWR a_13337_43633# 0.05353f
C1230 halfN/mon.A a_9954_39570# 0.17869f
C1231 a_18815_43229# VDPWR 0.31561f
C1232 VDPWR halfP/xq5.X 0.36406f
C1233 VDPWR a_18611_41623# 0.31924f
C1234 halfP/RDA.R2_8 halfP/RDA.R2_10 0.15162f
C1235 a_11334_42444# halfN/dff5.D 0.0227f
C1236 a_24805_40535# a_24805_39997# 0.01361f
C1237 halfP/obuf3.A halfP/xq5.B 0.20854f
C1238 uo_out[0] halfP/xq2.A 0.03795f
C1239 VDPWR a_25671_41891# 0.31659f
C1240 a_26119_43255# halfP/xq0.A 0.07434f
C1241 uo_out[6] uo_out[7] 0.18751f
C1242 VDPWR halfP/xq6.B 0.22687f
C1243 halfN/RDA.R2_20 halfN/RDA.R2_22 0.15162f
C1244 a_3811_41597# a_3811_42385# 0.01911f
C1245 a_15462_41989# a_15377_41623# 0.02068f
C1246 RBT.R1_2 RBT.R1_4 0.15162f
C1247 a_24805_43261# a_25246_43229# 0.08347f
C1248 ua[0] halfP/xq1.X 0.02855f
C1249 a_25503_43255# a_25246_43229# 0.0205f
C1250 VDPWR a_3811_40509# 0.5153f
C1251 a_10931_41775# uio_out[5] 0.02416f
C1252 VDPWR a_17949_43261# 0.25945f
C1253 a_4018_42444# a_3947_42545# 0.16113f
C1254 ui_in[6] ui_in[7] 0.01551f
C1255 VDPWR a_3527_40223# 0.15664f
C1256 VDPWR a_17305_41623# 0.26596f
C1257 halfP/RDA.R1_23 halfP/RDA.R1_21 0.15162f
C1258 a_11334_42444# uio_out[5] 0.01272f
C1259 a_15630_41735# a_15023_41623# 0.09081f
C1260 a_12499_43487# halfN/obuf6.A 0.02142f
C1261 halfN/obuf6.A halfN/xq3.A 2.40041f
C1262 halfN/dff5.D a_11221_43633# 0.0852f
C1263 a_24993_42167# a_24805_42173# 0.06685f
C1264 VDPWR a_16531_43255# 0.16201f
C1265 a_11334_42444# a_11263_42545# 0.16113f
C1266 a_11334_42444# a_11681_42545# 0.02068f
C1267 halfN/RDA.R2_8 halfN/xq1.X 0.15243f
C1268 halfN/xq6.X halfN/xq1.X 0.10624f
C1269 clk a_12919_43633# 0.01402f
C1270 halfP/obuf3.A a_25503_40901# 0.02208f
C1271 a_16239_42141# a_15207_42173# 0.02545f
C1272 VDPWR a_25671_42979# 0.31659f
C1273 halfP/obuf3.A halfP/xq0.X 0.01069f
C1274 ua[0] halfP/CM1.C2 0.77584f
C1275 a_25078_40901# a_24805_40535# 0.07623f
C1276 clk a_11127_42385# 0.16248f
C1277 VDPWR uio_oe[0] 0.3051f
C1278 a_24639_43261# halfP/xq1.A 0.01756f
C1279 halfP/dff4.D a_15786_39096# 0.09555f
C1280 halfP/dff2.D a_15561_42167# 0.0852f
C1281 a_3818_42985# a_3431_42863# 0.01914f
C1282 a_14183_42685# uio_out[0] 0.21333f
C1283 VDPWR tie_oe3.LO 0.29853f
C1284 uo_out[6] a_15483_42711# 0.01536f
C1285 halfN/obuf6.A a_3811_40509# 0.01017f
C1286 halfP/xq3.X a_26369_41873# 0.05743f
C1287 VDPWR a_16495_41623# 0.31847f
C1288 a_15814_42141# a_15373_42173# 0.08347f
C1289 VDPWR a_12067_42685# 0.32573f
C1290 halfP/xq3.X rst_n 0.05345f
C1291 a_3431_42399# halfN/xq2.A 0.02922f
C1292 a_3811_40509# a_3818_40809# 0.56916f
C1293 RB.R2_1 VDPWR 0.32336f
C1294 halfN/xq1.A halfN/xq0.X 0.01069f
C1295 VDPWR halfN/obuf3.A 0.78257f
C1296 uo_out[7] a_14839_42711# 0.21333f
C1297 a_17305_41623# a_18171_41891# 0.01914f
C1298 VDPWR a_16106_43255# 0.19716f
C1299 RB.R1_0 ua[1] 0.06062f
C1300 a_13243_42385# a_13450_42444# 0.16041f
C1301 a_3811_41597# a_3818_41897# 0.56916f
C1302 a_18526_39596# halfP/dff6.D 0.01177f
C1303 halfP/xq2.A a_26119_42167# 0.07434f
C1304 a_25246_39965# a_25078_39991# 0.16113f
C1305 a_24805_43261# a_24639_43261# 0.56916f
C1306 clk rst_n 0.13103f
C1307 a_15646_42167# halfP/dff4.D 0.01434f
C1308 rst_n halfP/xq6.X 0.89938f
C1309 a_25671_42979# halfP/xq1.B 0.07523f
C1310 clk uio_out[3] 0.30699f
C1311 a_25503_43255# a_24639_43261# 0.03079f
C1312 a_3431_42863# a_3431_42399# 0.01257f
C1313 a_12974_42985# a_13103_42711# 0.08347f
C1314 a_11518_41597# a_11865_41623# 0.02068f
C1315 halfP/xq3.A a_26119_41873# 0.07434f
C1316 a_17026_24748# a_24244_26120# 0.06359f
C1317 a_15922_43077# a_15649_42711# 0.07623f
C1318 halfP/dff4.D a_15483_42711# 0.06568f
C1319 uio_oe[0] halfN/obuf6.A 0.02453f
C1320 uio_oe[5] tie_oe7.LO 0.05207f
C1321 halfP/obuf6.A a_25503_41079# 0.02208f
C1322 a_10931_41775# a_11027_41597# 0.20625f
C1323 halfP/xq1.X a_26369_42961# 0.05751f
C1324 uio_out[6] halfN/xq0.A 0.02024f
C1325 clk uo_out[7] 0.4238f
C1326 a_10411_41597# VDPWR 0.31924f
C1327 VDPWR a_25078_43255# 0.19701f
C1328 halfP/RDA.R2_26 halfP/RIN.R2_1 0.01627f
C1329 halfN/obuf5.A a_3947_40369# 0.01931f
C1330 halfN/xq1.A a_3947_42711# 0.02017f
C1331 halfN/xq0.X ua[1] 0.02863f
C1332 halfN/xq0.X halfN/xq3.A 0.01069f
C1333 a_12990_43532# a_12790_43377# 0.07623f
C1334 a_12959_42399# halfN/dff4.D 0.0107f
C1335 uo_out[4] halfP/xq0.A 0.04343f
C1336 a_12783_43473# a_12919_43633# 0.09081f
C1337 a_24993_40535# a_24639_40535# 0.04548f
C1338 a_12067_42685# halfN/obuf6.A 0.2044f
C1339 halfN/xq0.A a_12863_42399# 0.04493f
C1340 halfN/obuf3.A halfN/obuf6.A 0.69821f
C1341 clk uio_oe[6] 0.13988f
C1342 halfP/obuf5.A a_24993_39991# 0.08683f
C1343 a_25503_43077# a_24639_42711# 0.03079f
C1344 halfN/obuf3.A a_3818_40809# 0.17307f
C1345 VDPWR a_25078_39991# 0.19596f
C1346 a_10674_43377# a_11221_43633# 0.06685f
C1347 a_15833_43261# halfP/xq0.A 0.04327f
C1348 a_3818_42985# a_3818_43377# 0.01371f
C1349 VDPWR a_12919_43633# 0.14718f
C1350 uio_out[4] a_11883_43229# 0.22108f
C1351 halfP/xq3.X halfP/RDA.R2_20 0.15218f
C1352 halfN/xq0.A a_12990_43532# 0.02203f
C1353 tie_oe4.LO uio_oe[4] 0.04918f
C1354 VDPWR a_24310_24722# 0.26453f
C1355 a_11127_42385# VDPWR 0.52739f
C1356 a_15462_41989# halfP/dff2.D 0.02145f
C1357 a_24993_42711# a_24639_42711# 0.04548f
C1358 a_25671_42141# halfP/xq2.A 0.02922f
C1359 a_17746_41735# a_17305_41623# 0.08347f
C1360 halfP/dff4.D a_15306_39570# 0.13442f
C1361 RBT.R2_0 halfP/RIN.R2_1 1.20113f
C1362 a_3811_41597# halfN/xq2.A 0.01017f
C1363 a_25503_39991# halfP/obuf5.A 0.02208f
C1364 clk a_24639_40535# 0.15601f
C1365 RBT.R2_0 ua[1] 0.29961f
C1366 VDPWR halfN/xq1.B 0.22607f
C1367 uio_oe[1] halfN/xq1.A 0.05388f
C1368 halfN/dff1.D a_11311_41597# 0.05259f
C1369 halfP/obuf6.A halfP/obuf3.A 0.69821f
C1370 VDPWR a_26119_40785# 0.14245f
C1371 a_3811_42385# a_3947_42545# 0.09081f
C1372 a_17493_41623# a_17305_41623# 0.06685f
C1373 VDPWR a_26201_39991# 0.01434f
C1374 clk a_15646_42167# 0.01016f
C1375 a_10874_43532# a_11221_43633# 0.02068f
C1376 halfP/dff1.D halfP/dff2.D 0.34713f
C1377 a_15207_42173# a_15561_42167# 0.04548f
C1378 VDPWR a_3185_40785# 0.01434f
C1379 halfN/CM1.C2 a_3464_26480# 1.3585f
C1380 VDPWR a_3527_43487# 0.15812f
C1381 a_18003_41989# a_17305_41623# 0.1112f
C1382 a_24805_41623# a_24993_41623# 0.06685f
C1383 VDPWR a_26369_41873# 0.16163f
C1384 a_26119_39991# halfP/xq6.X 0.11646f
C1385 clk a_15483_42711# 0.18763f
C1386 clk uio_oe[5] 0.09349f
C1387 VDPWR rst_n 0.37691f
C1388 a_2829_41079# halfN/xq4.X 0.05742f
C1389 halfN/dff5.D halfN/dff6.D 0.1145f
C1390 VDPWR uio_out[3] 0.40427f
C1391 halfN/CM1.C2 a_6022_24748# 2.67812f
C1392 VDPWR a_10227_42141# 0.32602f
C1393 tie_oe4.LO uio_oe[3] 0.01f
C1394 halfN/xq4.B a_2829_41079# 0.03769f
C1395 a_17026_24748# halfP/CM1.C2 1.28418f
C1396 halfP/dff6.D halfP/dff5.D 0.1145f
C1397 a_24639_41623# a_25503_41989# 0.03079f
C1398 a_12403_43487# halfN/xq1.A 0.09377f
C1399 halfP/RIN.R2_1 halfP/xq4.X 0.24633f
C1400 clk uo_out[1] 0.07243f
C1401 halfN/RDA.R1_11 halfN/RDA.R1_13 0.15162f
C1402 a_24993_40535# a_25078_40901# 0.02068f
C1403 uio_oe[1] halfN/xq3.A 0.02522f
C1404 VDPWR uo_out[7] 0.36274f
C1405 halfP/RDA.R2_16 halfP/RIN.R2_1 0.16817f
C1406 uo_out[5] a_15373_42173# 0.0162f
C1407 VDPWR a_2799_39965# 0.14114f
C1408 clk a_16347_43077# 0.01054f
C1409 a_25246_41735# a_24805_41623# 0.08347f
C1410 a_12959_42399# halfN/xq0.A 0.02245f
C1411 uo_out[1] uo_out[2] 0.40573f
C1412 a_24993_43255# a_24639_43261# 0.04548f
C1413 halfN/xq2.X a_6022_24748# 0.01539f
C1414 halfN/dff3.D a_10374_39596# 0.01167f
C1415 clk uo_out[3] 0.3248f
C1416 halfP/obuf6.A a_25671_41053# 0.02906f
C1417 a_3818_41201# a_3811_41297# 0.56916f
C1418 halfN/dff5.D halfN/dff4.D 0.11246f
C1419 a_25246_39965# a_24805_39997# 0.08347f
C1420 a_5356_24748# VDPWR 0.06927f
C1421 VDPWR a_15786_39096# 0.11063f
C1422 VDPWR uio_oe[6] 0.13218f
C1423 halfN/RIN.R2_1 a_3464_26480# 0.04096f
C1424 halfN/obuf3.A halfN/xq0.X 0.01069f
C1425 halfP/xq5.X halfP/xq4.X 3.6208f
C1426 VDPWR a_26369_40785# 0.16163f
C1427 uo_out[2] uo_out[3] 0.17546f
C1428 a_4365_42711# a_4018_42685# 0.02068f
C1429 halfN/RDA.R2_20 halfN/xq3.X 0.15218f
C1430 a_15207_42173# halfP/dff2.D 0.09341f
C1431 a_18611_41623# halfP/xq2.A 0.20393f
C1432 uio_out[7] a_10383_43487# 0.01934f
C1433 VDPWR a_11518_41597# 0.20025f
C1434 a_13243_42385# uio_out[2] 0.01382f
C1435 a_24805_41623# a_24805_42173# 0.01371f
C1436 VDPWR a_3527_42399# 0.15812f
C1437 halfP/dff5.D a_19486_39596# 0.01435f
C1438 halfP/xq1.A halfP/xq0.X 0.01069f
C1439 halfP/CM1.C2 RT.R1_6 0.01305f
C1440 a_15649_42711# a_15837_42711# 0.06685f
C1441 clk a_24639_41623# 0.15601f
C1442 halfN/RIN.R2_1 a_6022_24748# 0.0799f
C1443 uo_out[4] uo_out[5] 0.18241f
C1444 uio_out[3] halfN/obuf6.A 0.14024f
C1445 a_13243_42385# a_13797_42545# 0.04548f
C1446 halfP/xq2.X halfP/xq0.X 0.124f
C1447 halfP/xq2.B halfP/xq3.B 0.01221f
C1448 a_4018_40268# a_3811_40209# 0.16041f
C1449 a_4018_42444# a_3811_42385# 0.16041f
C1450 ui_in[1] ui_in[2] 0.01551f
C1451 RBT.R1_0 RT.R1_6 0.02312f
C1452 VDPWR a_25078_41989# 0.19701f
C1453 a_12499_43487# a_12403_43487# 0.20625f
C1454 halfN/RDA.R1_41 halfN/RDA.R1_43 0.15162f
C1455 VDPWR a_24639_40535# 0.5153f
C1456 halfN/xq1.B halfN/xq2.B 0.01239f
C1457 a_12974_42985# a_12587_42863# 0.01914f
C1458 a_3811_41297# a_3527_41311# 0.03079f
C1459 uo_out[4] a_16699_43229# 0.01058f
C1460 halfN/obuf5.A a_3818_40113# 0.17203f
C1461 VDPWR a_25671_43229# 0.31647f
C1462 a_17949_43261# halfP/xq2.A 0.04392f
C1463 VDPWR irst.Y 0.22154f
C1464 halfP/dff4.D a_15667_43261# 0.09549f
C1465 a_15646_42167# VDPWR 0.19716f
C1466 RB.R2_1 RBT.R2_0 5.8848f
C1467 RARR.R1_1 halfN/CM1.C2 0.17716f
C1468 a_11318_41897# a_11518_41597# 0.07623f
C1469 a_10667_43473# a_10383_43487# 0.03079f
C1470 a_15833_43261# a_16699_43229# 0.01914f
C1471 halfN/xq5.X halfN/xq6.X 3.26485f
C1472 halfP/xq3.B halfP/xq4.B 0.01239f
C1473 a_24805_40535# a_25246_40647# 0.08347f
C1474 VDPWR a_26119_39991# 0.14114f
C1475 ua[0] halfP/RIN.R2_1 0.32426f
C1476 VDPWR a_24805_39997# 0.25884f
C1477 VDPWR uio_oe[5] 0.07309f
C1478 VDPWR a_15483_42711# 0.5282f
C1479 a_24805_42173# a_25078_42167# 0.07623f
C1480 halfN/mon.A halfP/mon.A 0.14633f
C1481 halfN/RDA.R1_3 halfN/RDA.R1_1 0.15162f
C1482 ua[0] ua[1] 0.01889f
C1483 uio_oe[6] halfN/obuf6.A 0.02647f
C1484 uio_oe[1] uio_oe[0] 0.54671f
C1485 tie_oe4.LO uio_oe[2] 0.04912f
C1486 a_24805_42711# halfP/xq1.A 0.17659f
C1487 RT.R1_2 halfP/CM1.C2 0.01305f
C1488 VDPWR a_26119_41079# 0.14245f
C1489 halfP/RDA.R2_28 halfP/RDA.R2_26 0.15162f
C1490 uio_out[1] a_12527_41597# 0.2142f
C1491 a_2799_43229# a_2829_43255# 0.01818f
C1492 halfN/obuf5.A halfN/xq6.B 0.20854f
C1493 ua[0] halfP/xq5.X 0.08313f
C1494 halfN/xq0.B halfN/xq1.B 0.01221f
C1495 uio_oe[1] tie_oe3.LO 0.04475f
C1496 a_24805_43261# halfP/xq1.A 0.01279f
C1497 VDPWR uo_out[1] 0.45276f
C1498 a_24639_43261# a_24639_42711# 0.01911f
C1499 VDPWR a_25671_39965# 0.31612f
C1500 a_16021_43255# halfP/dff4.D 0.0852f
C1501 uo_out[1] a_17323_42173# 0.01286f
C1502 a_17677_42167# halfP/dff3.D 0.0859f
C1503 a_6022_24748# halfN/xq4.X 0.02304f
C1504 VDPWR a_16347_43077# 0.16232f
C1505 uio_out[4] halfN/xq1.A 0.0989f
C1506 RBT.R2_0 RT.R2_3 0.03926f
C1507 a_3947_42545# halfN/xq2.A 0.01976f
C1508 a_17139_41623# halfP/dff5.D 0.02396f
C1509 VDPWR uo_out[3] 0.36162f
C1510 VDPWR a_15306_39570# 4.23244f
C1511 halfP/dff6.D a_15189_41623# 0.04013f
C1512 halfP/xq0.B halfP/xq0.A 0.20868f
C1513 halfP/obuf6.A halfP/xq0.X 0.01069f
C1514 a_16531_43255# uo_out[4] 0.01053f
C1515 a_13521_42711# halfN/dff6.D 0.08245f
C1516 a_24805_43261# a_24805_42711# 0.01371f
C1517 halfN/mon.A a_12774_39596# 0.01242f
C1518 a_12587_42863# halfN/xq3.A 0.03559f
C1519 VDPWR a_25078_40901# 0.19701f
C1520 a_25078_42167# a_25246_42141# 0.16113f
C1521 VDPWR a_24639_41623# 0.5153f
C1522 a_3431_41775# halfN/xq3.A 0.02906f
C1523 a_25078_43077# a_24993_42711# 0.02068f
C1524 uio_oe[3] halfN/xq3.A 0.02219f
C1525 a_15833_43261# a_16531_43255# 0.1112f
C1526 clk a_15667_43261# 0.2006f
C1527 halfP/dff4.D a_16071_42167# 0.0107f
C1528 halfN/dff3.D a_11134_42289# 0.16457f
C1529 a_10931_41775# VDPWR 0.32239f
C1530 a_4365_40369# a_3818_40113# 0.06685f
C1531 halfN/dff2.D halfN/dff6.D 0.98981f
C1532 a_25503_43255# a_24805_43261# 0.1112f
C1533 uio_in[1] uio_in[2] 0.01551f
C1534 halfN/RDA.R1_11 halfN/RDA.R1_9 0.15162f
C1535 halfN/xq0.A uio_out[5] 0.02211f
C1536 clk a_17783_43261# 0.164f
C1537 uio_oe[7] halfN/xq0.A 0.03085f
C1538 uio_out[1] halfN/dff6.D 0.09162f
C1539 a_26369_39991# halfP/xq6.X 0.0574f
C1540 a_3527_40509# a_3431_40687# 0.20625f
C1541 halfP/obuf6.A halfP/xq1.A 1.60219f
C1542 a_10747_42399# uio_out[6] 0.02237f
C1543 halfP/xq4.B a_25671_41053# 0.07523f
C1544 VDPWR a_11334_42444# 0.19813f
C1545 uo_out[2] a_17783_43261# 0.01117f
C1546 halfN/dff4.D a_13521_42711# 0.01216f
C1547 uio_out[4] halfN/xq3.A 0.01919f
C1548 uio_out[6] a_11134_42289# 0.01568f
C1549 a_24639_39997# a_25078_39991# 0.16041f
C1550 a_3527_42685# a_3431_42863# 0.20625f
C1551 RBT.R2_0 rst_n 0.31534f
C1552 a_10931_41775# a_11318_41897# 0.01914f
C1553 a_17762_42167# a_17930_42141# 0.16113f
C1554 a_24993_42167# VDPWR 0.05353f
C1555 halfP/obuf3.A a_24805_40535# 0.17307f
C1556 a_3818_41897# a_3527_41597# 0.1112f
C1557 halfP/dff6.D a_15023_41623# 0.04284f
C1558 halfN/dff2.D halfN/dff4.D 0.25347f
C1559 a_13797_42545# a_13450_42444# 0.02068f
C1560 a_15833_43261# a_16106_43255# 0.07623f
C1561 halfP/xq2.X a_19300_24748# 0.01539f
C1562 halfN/dff4.D uio_out[1] 0.09409f
C1563 VDPWR a_19255_43255# 0.30695f
C1564 halfN/dff3.D a_11447_41623# 0.01531f
C1565 clk halfP/obuf5.A 0.91738f
C1566 halfN/xq5.X halfN/xq1.X 0.10298f
C1567 a_12967_42685# halfN/dff6.D 0.05224f
C1568 halfP/xq3.A a_24639_42173# 0.01412f
C1569 halfN/RIN.R2_1 halfN/CM1.C2 0.11267p
C1570 a_3818_42985# a_3811_42685# 0.56916f
C1571 VDPWR a_11221_43633# 0.05353f
C1572 a_4018_42444# halfN/xq2.A 0.01543f
C1573 halfP/xq5.B halfP/xq4.B 0.01221f
C1574 a_3431_41311# a_3811_41297# 0.02545f
C1575 a_3947_40535# a_3811_40509# 0.09081f
C1576 clk a_12527_41597# 0.03615f
C1577 uio_out[1] a_13047_41775# 0.01528f
C1578 halfN/xq0.A a_3818_43377# 0.17322f
C1579 a_10747_42399# a_11134_42289# 0.01914f
C1580 VDPWR a_18187_42167# 0.16327f
C1581 a_18355_42141# a_17489_42173# 0.01914f
C1582 a_3818_42985# VDPWR 0.25972f
C1583 a_18187_42167# a_17323_42173# 0.03079f
C1584 a_2829_42167# VDPWR 0.16163f
C1585 a_5356_24748# RBT.R2_0 4.51516f
C1586 VDPWR a_3947_40369# 0.14333f
C1587 a_2829_39991# a_2799_39965# 0.01818f
C1588 clk a_16071_42167# 0.01676f
C1589 a_16090_42823# halfP/xq0.A 0.01511f
C1590 halfP/CM1.C2 a_24244_26120# 0.03132f
C1591 a_2799_41808# halfN/xq3.B 0.22941f
C1592 a_17026_24748# halfP/RIN.R2_1 4.86621f
C1593 rst_n halfP/xq4.X 0.08343f
C1594 a_12967_42685# halfN/dff4.D 0.06568f
C1595 halfN/RIN.R2_1 halfN/xq2.X 0.24759f
C1596 a_17949_43261# a_18137_43255# 0.06685f
C1597 halfP/RDA.R1_39 halfP/RDA.R1_41 0.15162f
C1598 a_4018_41597# a_3811_41597# 0.16041f
C1599 uio_oe[3] tie_oe3.LO 0.04456f
C1600 a_12959_42399# a_12863_42399# 0.20625f
C1601 clk a_3811_41597# 0.15601f
C1602 tie_oe2.LO uio_oe[2] 0.05023f
C1603 halfP/RDA.R2_2 halfP/xq0.X 0.15273f
C1604 a_2799_43229# halfN/xq0.A 0.07434f
C1605 a_3947_43633# a_3818_43377# 0.08347f
C1606 a_25246_39965# halfP/obuf5.A 0.01931f
C1607 a_15922_43077# halfP/dff4.D 0.02233f
C1608 VDPWR a_15667_43261# 0.52278f
C1609 halfP/xq1.A a_26119_42961# 0.07434f
C1610 a_4365_41623# halfN/xq3.A 0.08724f
C1611 uio_oe[2] halfN/xq3.A 0.04535f
C1612 VDPWR a_17783_43261# 0.51616f
C1613 VDPWR a_26369_39991# 0.16163f
C1614 VDPWR a_3431_42399# 0.31659f
C1615 a_24805_41623# a_25503_41989# 0.1112f
C1616 RBT.R2_0 irst.Y 3.81553f
C1617 a_17139_43255# uo_out[3] 0.22108f
C1618 halfP/RDA.R1_1 halfP/RDA.R1_3 0.15162f
C1619 a_15023_41623# a_15189_41623# 0.56916f
C1620 halfN/xq6.X ua[1] 0.22364f
C1621 ua[0] a_24310_24722# 0.01136f
C1622 RT.R2_5 RBT.R2_0 0.20912f
C1623 a_3811_40509# a_4018_40509# 0.16041f
C1624 a_24639_41085# a_24639_40535# 0.01911f
C1625 clk a_13143_41597# 0.01623f
C1626 halfN/CM1.C2 halfN/xq4.X 0.01715f
C1627 clk halfN/dff6.D 0.24174f
C1628 clk a_13563_41623# 0.01041f
C1629 halfP/dff5.D a_17489_42173# 0.05103f
C1630 halfP/xq2.X halfP/xq2.B 0.01332f
C1631 a_12403_43487# uio_out[3] 0.01058f
C1632 uio_out[1] uio_out[0] 0.18751f
C1633 a_24805_43261# a_24993_43255# 0.06685f
C1634 halfN/obuf3.A a_3947_40535# 0.01931f
C1635 VDPWR a_25503_43077# 0.15812f
C1636 a_18390_43229# VDPWR 0.14346f
C1637 a_10803_43633# a_10383_43487# 0.0205f
C1638 halfN/xq0.A uio_out[1] 0.1014f
C1639 RT.R1_6 ua[1] 0.01193f
C1640 clk halfP/dff3.D 0.02921f
C1641 a_24639_39997# a_24639_40535# 0.02056f
C1642 a_16021_43255# VDPWR 0.05353f
C1643 a_3811_43473# halfN/xq0.A 0.09558f
C1644 uo_out[0] halfP/xq3.A 0.02367f
C1645 VDPWR a_24993_42711# 0.05353f
C1646 VDPWR halfP/obuf5.A 0.73172f
C1647 a_12967_42685# a_12683_42685# 0.03079f
C1648 halfN/dff5.D halfN/dff3.D 0.68035f
C1649 uo_out[2] halfP/dff3.D 0.05257f
C1650 halfN/xq2.X halfN/xq4.X 0.10632f
C1651 halfN/RDA.R2_32 halfN/RIN.R2_1 0.01627f
C1652 clk halfN/dff4.D 0.26512f
C1653 ua[0] rst_n 0.73429f
C1654 a_4365_43633# halfN/xq0.A 0.08753f
C1655 halfN/xq6.B halfN/xq5.B 0.01239f
C1656 clk a_16239_42141# 0.01807f
C1657 VDPWR a_12527_41597# 0.31847f
C1658 uio_out[6] halfN/xq2.A 0.13932f
C1659 a_3811_43473# a_3947_43633# 0.09081f
C1660 VDPWR a_4365_40535# 0.05353f
C1661 a_24639_39997# a_24805_39997# 0.56916f
C1662 a_2829_42167# halfN/xq2.B 0.03769f
C1663 halfN/dff5.D uio_out[6] 0.06027f
C1664 halfN/RIN.R2_1 halfN/RDA.R2_16 0.16817f
C1665 clk a_15922_43077# 0.01273f
C1666 halfN/RIN.R2_1 halfN/xq4.X 0.24633f
C1667 uio_oe[2] uio_oe[0] 0.13255f
C1668 VDPWR a_16071_42167# 0.16233f
C1669 clk a_13047_41775# 0.02344f
C1670 a_12967_42685# halfN/xq0.A 0.02137f
C1671 halfP/xq1.A a_24639_42711# 0.10013f
C1672 a_15646_42167# a_15373_42173# 0.07623f
C1673 halfN/obuf3.A a_4018_40509# 0.01515f
C1674 halfN/dff3.D uio_out[5] 0.05257f
C1675 halfP/CM1.C2 RBT.R1_0 0.01305f
C1676 VDPWR a_3811_41597# 0.5153f
C1677 uio_oe[2] tie_oe3.LO 0.01567f
C1678 a_3818_42289# halfN/xq3.A 0.01037f
C1679 halfP/mon.A halfP/dff5.D 0.17011f
C1680 RT.R1_2 ua[1] 0.01193f
C1681 halfP/xq3.X halfP/xq3.B 0.01331f
C1682 a_24639_39997# a_25671_39965# 0.02545f
C1683 RB.R2_1 a_17026_24748# 2.21721f
C1684 a_24805_42711# a_24805_42173# 0.01361f
C1685 halfP/xq4.X a_26119_41079# 0.11648f
C1686 a_11681_42545# halfN/dff3.D 0.0859f
C1687 a_3431_42399# halfN/xq2.B 0.07523f
C1688 halfP/obuf3.A a_24993_40535# 0.08703f
C1689 a_25503_40901# a_24805_40535# 0.1112f
C1690 VDPWR tie_oe5.LO 0.29851f
C1691 uio_oe[4] uio_oe[6] 0.12871f
C1692 a_24639_41623# a_24639_41085# 0.02056f
C1693 a_24805_42711# a_24639_42711# 0.56916f
C1694 clk a_24639_43261# 0.15561f
C1695 VDPWR a_2829_43255# 0.16163f
C1696 uio_out[6] uio_out[5] 0.40573f
C1697 a_3811_42385# halfN/xq2.A 0.09482f
C1698 uo_out[1] halfP/xq2.A 0.13932f
C1699 a_10747_42399# halfN/xq2.A 0.04503f
C1700 uio_out[3] a_12587_42863# 0.02178f
C1701 clk a_12683_42685# 0.01054f
C1702 VDPWR a_13563_41623# 0.14524f
C1703 VDPWR halfN/dff6.D 0.55986f
C1704 VDPWR a_13143_41597# 0.16115f
C1705 VDPWR a_3818_40113# 0.25884f
C1706 VDPWR a_25246_43229# 0.14313f
C1707 VDPWR a_25246_40647# 0.14313f
C1708 a_16955_42711# halfP/obuf6.A 0.2044f
C1709 halfN/xq5.X a_2799_40720# 0.11653f
C1710 a_10667_43473# a_10803_43633# 0.09081f
C1711 halfN/CM1.C2 a_5130_26120# 0.03132f
C1712 halfP/xq3.A halfP/xq0.A 1.89169f
C1713 a_16515_42979# a_15483_42711# 0.02545f
C1714 halfN/dff5.D a_11134_42289# 0.05103f
C1715 a_4365_40535# a_3818_40809# 0.06685f
C1716 clk a_12790_43377# 0.0638f
C1717 clk a_16274_43229# 0.01402f
C1718 clk halfP/obuf3.A 0.61028f
C1719 uo_out[6] halfP/dff2.D 0.05735f
C1720 halfP/dff4.D a_15837_42711# 0.01216f
C1721 halfP/obuf6.A halfP/xq4.B 0.20854f
C1722 VDPWR halfP/dff3.D 0.59458f
C1723 halfN/xq1.X ua[1] 0.02855f
C1724 a_17323_42173# halfP/dff3.D 0.09566f
C1725 clk uio_out[0] 0.4238f
C1726 a_12783_43473# halfN/dff4.D 0.09549f
C1727 uio_out[3] uio_out[4] 0.21359f
C1728 a_24639_41623# halfP/xq2.A 0.01017f
C1729 halfP/mon.A halfP/dff6.D 0.01329f
C1730 VDPWR a_24805_41623# 0.25972f
C1731 VDPWR a_2799_42896# 0.14245f
C1732 clk halfN/xq0.A 0.79048f
C1733 clk a_12343_42141# 0.03677f
C1734 a_18611_41623# halfP/dff5.D 0.01898f
C1735 VDPWR a_26201_43255# 0.01434f
C1736 a_18222_43255# VDPWR 0.19596f
C1737 halfN/xq4.B halfN/xq4.X 0.0133f
C1738 a_10854_39596# halfN/dff6.D 0.01177f
C1739 VDPWR halfN/dff4.D 0.71141f
C1740 uio_out[7] halfN/xq1.A 0.02054f
C1741 a_13634_41597# a_13563_41623# 0.16113f
C1742 a_16055_41891# a_15189_41623# 0.01914f
C1743 a_13634_41597# halfN/dff6.D 0.02112f
C1744 uio_oe[4] uio_oe[5] 0.3235f
C1745 a_16239_42141# VDPWR 0.3223f
C1746 a_16515_42979# a_16347_43077# 0.20625f
C1747 a_26119_41873# a_26369_41873# 0.01818f
C1748 uo_out[5] halfP/dff6.D 0.01244f
C1749 VDPWR halfN/xq6.B 0.22687f
C1750 a_11134_42289# uio_out[5] 0.02549f
C1751 a_17026_24748# a_24310_24722# 0.02508f
C1752 ui_in[6] ui_in[5] 0.01551f
C1753 a_15922_43077# VDPWR 0.20115f
C1754 a_3818_42985# a_3947_42711# 0.08347f
C1755 uo_out[4] uo_out[3] 0.21359f
C1756 halfP/dff4.D halfP/dff2.D 0.25347f
C1757 a_17949_43261# halfP/dff5.D 0.16439f
C1758 VDPWR a_13047_41775# 0.32259f
C1759 halfP/RDA.R1_43 halfP/RDA.R1_41 0.15162f
C1760 a_11134_42289# a_11263_42545# 0.08347f
C1761 VDPWR a_25503_41079# 0.15812f
C1762 a_25671_42141# a_24639_42173# 0.02545f
C1763 halfN/dff5.D a_11447_41623# 0.01531f
C1764 VDPWR a_2829_41079# 0.16163f
C1765 a_11681_42545# a_11134_42289# 0.06685f
C1766 a_3818_40809# a_3818_40113# 0.01361f
C1767 a_17305_41623# halfP/dff5.D 0.06364f
C1768 uio_out[6] a_10674_43377# 0.01551f
C1769 a_24993_42167# halfP/xq2.A 0.08717f
C1770 VDPWR a_25078_42167# 0.19701f
C1771 halfP/RDA.R1_9 halfP/RDA.R1_7 0.15162f
C1772 a_25503_42167# a_24805_42173# 0.1112f
C1773 uo_out[0] halfP/xq0.A 0.02543f
C1774 VDPWR a_2829_42961# 0.16163f
C1775 halfN/dff2.D a_13981_41623# 0.01238f
C1776 a_12974_42985# a_13174_42685# 0.07623f
C1777 halfP/RDA.R1_9 halfP/RDA.R1_11 0.15162f
C1778 VDPWR a_15377_41623# 0.05353f
C1779 VDPWR a_24639_43261# 0.5153f
C1780 uio_out[7] halfN/xq3.A 0.01936f
C1781 VDPWR halfP/xq3.B 0.22607f
C1782 uio_oe[3] uio_oe[5] 0.03922f
C1783 a_12783_43473# a_12790_43377# 0.56916f
C1784 a_13250_42289# halfN/dff6.D 0.04636f
C1785 halfP/obuf6.A a_24993_41079# 0.08699f
C1786 a_15023_41623# a_16055_41891# 0.02545f
C1787 uio_out[5] a_11447_41623# 0.01454f
C1788 VDPWR a_12683_42685# 0.16232f
C1789 a_18187_42167# halfP/xq2.A 0.02342f
C1790 halfP/dff1.D halfP/dff4.D 0.17864f
C1791 halfP/mon.A a_15189_41623# 0.13009f
C1792 VDPWR a_12790_43377# 0.26719f
C1793 VDPWR halfP/obuf3.A 0.78192f
C1794 VDPWR a_16274_43229# 0.14718f
C1795 a_17578_41989# uo_out[2] 0.01256f
C1796 halfN/xq0.A a_3811_42685# 0.01017f
C1797 a_12783_43473# halfN/xq0.A 0.04609f
C1798 halfN/RDA.R1_39 halfN/RDA.R1_41 0.15162f
C1799 VDPWR uio_out[0] 0.36274f
C1800 halfN/xq4.B halfN/xq3.B 0.01239f
C1801 a_10287_43487# halfN/obuf5.A 0.10467f
C1802 VDPWR a_3527_40509# 0.15812f
C1803 a_12974_42985# uio_out[2] 0.01178f
C1804 VDPWR halfN/xq0.A 0.74321f
C1805 uo_out[6] a_15207_42173# 0.01663f
C1806 VDPWR a_18647_43255# 0.1567f
C1807 uio_in[7] uo_out[0] 0.01571f
C1808 VDPWR a_12343_42141# 0.32715f
C1809 a_13250_42289# halfN/dff4.D 0.04468f
C1810 halfP/xq3.A uo_out[5] 0.09407f
C1811 a_2829_43255# halfN/xq0.B 0.03769f
C1812 VDPWR a_3947_42545# 0.14313f
C1813 a_25503_42167# a_25246_42141# 0.0205f
C1814 clk halfP/dff2.D 0.19853f
C1815 halfN/obuf3.A a_10383_43487# 0.03163f
C1816 rst_n RT.R1_6 0.04898f
C1817 a_17783_43261# halfP/xq2.A 0.04668f
C1818 uio_in[2] uio_in[3] 0.01551f
C1819 halfP/RDA.R2_38 halfP/RDA.R2_40 0.15162f
C1820 a_9954_39096# halfN/dff6.D 0.09141f
C1821 halfN/RIN.R2_1 halfN/RDA.R2_22 0.16817f
C1822 a_2829_43255# halfN/xq0.X 0.06151f
C1823 a_2799_39965# halfN/xq6.X 0.11646f
C1824 uo_out[2] a_17930_42141# 0.01099f
C1825 a_17746_41735# halfP/dff3.D 0.01531f
C1826 halfP/xq1.X halfP/RIN.R2_1 0.24984f
C1827 a_3527_42685# a_3811_42685# 0.03079f
C1828 halfN/dff5.D halfN/xq2.A 0.10293f
C1829 VDPWR a_3947_43633# 0.14313f
C1830 halfP/RDA.R2_14 halfP/RIN.R2_1 0.01627f
C1831 a_3811_42685# a_4018_42685# 0.16041f
C1832 a_9767_43229# halfN/obuf5.A 0.23309f
C1833 halfN/RDA.R1_15 halfN/RDA.R1_13 0.15162f
C1834 a_25078_43077# halfP/xq1.A 0.01672f
C1835 halfP/mon.A a_15023_41623# 0.06481f
C1836 a_24639_39997# halfP/obuf5.A 0.09393f
C1837 a_18390_43229# halfP/xq2.A 0.02793f
C1838 halfN/dff3.D a_11865_41623# 0.01253f
C1839 halfP/xq3.X halfP/xq0.X 0.12143f
C1840 a_10287_43487# a_10674_43377# 0.01914f
C1841 a_3527_42685# VDPWR 0.15812f
C1842 halfP/dff3.D a_17493_41623# 0.01253f
C1843 uio_out[7] uio_oe[0] 0.087f
C1844 halfP/dff4.D a_15207_42173# 0.03816f
C1845 halfN/xq3.X a_6022_24748# 0.02026f
C1846 irst.Y a_17026_24748# 0.17243f
C1847 VDPWR a_15561_42167# 0.05353f
C1848 VDPWR a_4018_42685# 0.19701f
C1849 a_3811_40209# a_3431_40223# 0.02545f
C1850 halfN/xq1.A a_11883_43229# 0.22401f
C1851 VDPWR a_3185_41079# 0.01434f
C1852 halfP/xq3.A a_25671_41891# 0.02906f
C1853 RBT.R2_3 RBT.R2_1 0.15162f
C1854 VDPWR a_25671_41053# 0.31659f
C1855 VDPWR a_3464_26480# 0.26453f
C1856 halfP/xq1.X halfP/xq5.X 0.10298f
C1857 halfN/dff4.D a_9954_39096# 0.09555f
C1858 halfP/xq6.X halfP/xq0.X 0.12351f
C1859 clk halfP/dff1.D 0.01242f
C1860 a_24805_42711# a_25078_43077# 0.07623f
C1861 clk a_14183_42685# 0.06312f
C1862 a_15833_43261# a_15667_43261# 0.56916f
C1863 a_10843_42399# a_11127_42385# 0.03079f
C1864 a_3527_40509# a_3818_40809# 0.1112f
C1865 uio_out[5] halfN/xq2.A 0.10904f
C1866 VDPWR a_6022_24748# 7.65026f
C1867 uio_oe[7] halfN/xq2.A 0.03141f
C1868 RT.R1_2 rst_n 0.04648f
C1869 halfP/CM1.C2 halfP/RIN.R2_1 0.11267p
C1870 uio_out[7] halfN/obuf3.A 0.07344f
C1871 VDPWR a_15837_42711# 0.05353f
C1872 a_11027_41597# a_11447_41623# 0.0205f
C1873 halfP/xq0.B a_25671_43229# 0.07523f
C1874 halfN/dff5.D uio_out[5] 0.20942f
C1875 VDPWR a_17578_41989# 0.20025f
C1876 a_2799_41808# halfN/xq3.X 0.1166f
C1877 halfP/xq2.X halfP/xq3.X 4.09547f
C1878 halfP/xq0.A a_16055_41891# 0.08716f
C1879 halfN/dff5.D a_11263_42545# 0.02581f
C1880 halfN/dff1.D a_11814_39596# 0.01201f
C1881 a_2799_42141# a_2829_42167# 0.01818f
C1882 clk halfN/dff3.D 0.02921f
C1883 uio_out[2] halfN/xq3.A 0.09407f
C1884 RBT.R1_0 ua[1] 0.01193f
C1885 clk halfP/xq1.A 0.42632f
C1886 a_17762_42167# a_17677_42167# 0.02068f
C1887 RB.R2_1 a_24244_26120# 0.11661f
C1888 halfN/xq1.B halfN/xq1.X 0.01333f
C1889 a_16531_43255# halfP/xq3.A 0.02445f
C1890 a_13379_42545# halfN/dff4.D 0.0255f
C1891 halfP/dff4.D a_15649_42711# 0.05593f
C1892 halfP/xq2.X halfP/xq6.X 0.10646f
C1893 uo_out[2] halfP/xq1.A 0.0315f
C1894 halfP/CM1.C2 halfP/xq5.X 0.01797f
C1895 a_4018_42444# VDPWR 0.19701f
C1896 VDPWR halfP/RDA.R1_21 0.0106f
C1897 VDPWR halfP/xq5.B 0.22607f
C1898 VDPWR a_2799_41808# 0.14245f
C1899 a_15373_42173# a_16071_42167# 0.1112f
C1900 halfN/dff1.D halfN/dff6.D 0.08704f
C1901 a_10667_43473# halfN/obuf3.A 0.01871f
C1902 halfN/RDA.R2_38 halfN/RIN.R2_1 0.01627f
C1903 clk uio_out[6] 0.07243f
C1904 a_16021_43255# a_15833_43261# 0.06685f
C1905 VDPWR halfP/dff2.D 0.581f
C1906 a_18815_43229# uo_out[0] 0.0339f
C1907 VDPWR a_17930_42141# 0.14792f
C1908 a_17139_41623# a_17305_41623# 0.56916f
C1909 a_17323_42173# a_17930_42141# 0.09081f
C1910 a_4018_41356# a_4365_41457# 0.02068f
C1911 uio_out[5] a_11263_42545# 0.01099f
C1912 a_13103_42711# halfN/dff4.D 0.01017f
C1913 a_2799_41053# a_2829_41079# 0.01818f
C1914 a_3527_42399# a_3818_42289# 0.1112f
C1915 clk a_15207_42173# 0.19991f
C1916 clk a_12863_42399# 0.01807f
C1917 a_3811_40209# a_3811_40509# 0.02056f
C1918 halfN/xq5.X ua[1] 0.08313f
C1919 a_2829_39991# halfN/xq6.B 0.03769f
C1920 a_3811_40209# a_3527_40223# 0.03079f
C1921 VDPWR a_15462_41989# 0.20013f
C1922 halfN/dff1.D halfN/dff4.D 0.17864f
C1923 a_3431_41775# a_3431_42399# 0.01302f
C1924 a_24805_42173# a_25246_42141# 0.08347f
C1925 a_10674_43377# halfN/xq2.A 0.04392f
C1926 clk a_12990_43532# 0.01491f
C1927 uio_oe[7] halfN/obuf5.A 0.04501f
C1928 halfP/RIN.R2_1 halfP/RDA.R2_32 0.01627f
C1929 halfN/dff5.D a_10674_43377# 0.16439f
C1930 a_24639_41085# a_25503_41079# 0.03079f
C1931 halfP/RDA.R1_15 halfP/RDA.R1_13 0.15162f
C1932 halfN/xq0.B halfN/xq0.A 0.20868f
C1933 VDPWR a_3527_41597# 0.15812f
C1934 a_15786_39096# halfP/dff5.D 0.30825f
C1935 clk a_3811_42385# 0.15601f
C1936 VDPWR a_25503_40901# 0.15812f
C1937 VDPWR halfP/xq0.X 0.4675f
C1938 halfP/dff1.D VDPWR 0.45064f
C1939 a_3527_43487# a_3431_43487# 0.20625f
C1940 a_18222_43255# halfP/xq2.A 0.02273f
C1941 halfP/RDA.R1_35 halfP/RDA.R1_33 0.15162f
C1942 VDPWR a_14183_42685# 0.35062f
C1943 uo_out[5] halfP/xq0.A 0.12585f
C1944 clk a_11134_42289# 0.01723f
C1945 a_10874_43532# halfN/xq2.A 0.02273f
C1946 halfP/xq5.X halfP/RDA.R2_32 0.15209f
C1947 halfN/dff5.D a_11027_41597# 0.03402f
C1948 clk a_15649_42711# 0.03697f
C1949 clk halfP/obuf6.A 0.63795f
C1950 a_3947_41623# halfN/xq3.A 0.01986f
C1951 uo_out[1] a_18355_42141# 0.02237f
C1952 VDPWR a_13981_41623# 0.05353f
C1953 halfN/obuf3.A a_2799_40720# 0.07434f
C1954 a_13103_42711# a_12683_42685# 0.0205f
C1955 uo_out[2] halfP/obuf6.A 0.0229f
C1956 VDPWR halfN/dff3.D 0.59458f
C1957 a_19300_24748# halfP/xq3.X 0.02026f
C1958 RB.R2_1 halfP/CM1.C2 2.96206f
C1959 a_17783_43261# a_18137_43255# 0.04548f
C1960 a_16239_42141# a_15373_42173# 0.01914f
C1961 VDPWR halfP/xq1.A 0.61848f
C1962 uio_oe[4] tie_oe5.LO 0.01295f
C1963 halfP/xq2.X VDPWR 0.35198f
C1964 a_16090_42823# a_15483_42711# 0.09081f
C1965 halfN/dff2.D a_11334_39596# 0.01187f
C1966 halfN/dff5.D halfN/dff2.D 0.11338f
C1967 a_25078_42167# halfP/xq2.A 0.01543f
C1968 a_25503_43077# a_25246_42823# 0.0205f
C1969 a_24639_41085# halfP/obuf3.A 0.01218f
C1970 a_15786_39096# halfP/dff6.D 0.09141f
C1971 VDPWR uio_out[6] 0.45276f
C1972 a_17578_41989# a_17746_41735# 0.16113f
C1973 uio_out[5] a_11027_41597# 0.0161f
C1974 VDPWR a_24805_42711# 0.25972f
C1975 a_11318_41897# halfN/dff3.D 0.06002f
C1976 a_13103_42711# halfN/xq0.A 0.01511f
C1977 clk a_12959_42399# 0.01676f
C1978 a_13981_41623# a_13634_41597# 0.02068f
C1979 VDPWR a_24805_43261# 0.25972f
C1980 a_3811_41597# a_3431_41775# 0.02545f
C1981 halfP/xq2.X a_26369_42167# 0.05746f
C1982 VDPWR a_12863_42399# 0.3223f
C1983 VDPWR halfN/CM1.C2 2.15939f
C1984 VDPWR a_15207_42173# 0.52614f
C1985 a_12783_43473# a_12990_43532# 0.16041f
C1986 a_17578_41989# a_17493_41623# 0.02068f
C1987 halfP/obuf6.A a_25078_41079# 0.01515f
C1988 a_16090_42823# a_16347_43077# 0.0205f
C1989 VDPWR a_25503_43255# 0.15812f
C1990 a_13427_41597# a_13563_41623# 0.09081f
C1991 uo_out[1] halfP/dff5.D 0.06027f
C1992 a_13427_41597# halfN/dff6.D 0.04284f
C1993 a_13427_41597# a_13143_41597# 0.03079f
C1994 a_4018_41597# a_3818_41897# 0.07623f
C1995 halfP/xq1.B halfP/xq1.A 0.20854f
C1996 halfN/xq3.X halfN/xq2.X 4.09547f
C1997 halfN/RDA.R2_26 halfN/RIN.R2_1 0.01627f
C1998 halfN/mon.A halfN/dff6.D 0.01329f
C1999 a_3811_42385# a_3811_42685# 0.02056f
C2000 VDPWR a_12990_43532# 0.19716f
C2001 halfP/obuf3.A halfP/xq2.A 1.29772f
C2002 uio_oe[3] tie_oe5.LO 0.04581f
C2003 a_15646_42167# halfP/dff6.D 0.0242f
C2004 halfN/RIN.R2_1 halfN/RDA.R2_2 0.01627f
C2005 a_25246_41053# a_25503_41079# 0.0205f
C2006 a_25671_40803# a_24639_40535# 0.02545f
C2007 a_3527_42685# a_3947_42711# 0.0205f
C2008 a_15306_39570# halfP/dff5.D 0.22526f
C2009 a_3947_42711# a_4018_42685# 0.16113f
C2010 uio_oe[1] halfN/xq0.A 0.02633f
C2011 VDPWR a_3811_42385# 0.5153f
C2012 VDPWR a_10747_42399# 0.32214f
C2013 halfP/xq1.X rst_n 0.02603f
C2014 a_13434_41897# a_13563_41623# 0.08347f
C2015 a_13434_41897# halfN/dff6.D 0.04013f
C2016 halfN/xq4.B halfN/xq5.B 0.01221f
C2017 a_13434_41897# a_13143_41597# 0.1112f
C2018 VDPWR halfN/xq2.X 0.37249f
C2019 a_4018_40268# a_3947_40369# 0.16113f
C2020 a_15483_42711# halfP/dff6.D 0.05224f
C2021 halfP/RDA.R1_7 halfP/RDA.R1_5 0.15162f
C2022 halfN/RIN.R2_1 halfN/xq3.X 0.24673f
C2023 halfN/RDA.R2_10 halfN/RDA.R2_8 0.15162f
C2024 halfP/RIN.R2_1 halfP/RDA.R2_22 0.16817f
C2025 halfP/CM1.C2 a_24310_24722# 1.3585f
C2026 RBT.R2_0 a_6022_24748# 3.97272f
C2027 a_26369_43255# halfP/xq0.X 0.06151f
C2028 halfN/obuf5.A a_4365_40369# 0.08683f
C2029 uio_out[6] halfN/obuf6.A 0.01867f
C2030 VDPWR a_11134_42289# 0.26898f
C2031 a_11127_42385# uio_out[2] 0.01003f
C2032 halfN/dff4.D a_13427_41597# 0.01863f
C2033 a_24639_41085# a_25671_41053# 0.02545f
C2034 VDPWR a_4365_41457# 0.05353f
C2035 halfN/mon.A halfN/dff4.D 0.41201f
C2036 a_25246_41735# a_25503_41989# 0.0205f
C2037 VDPWR a_15649_42711# 0.26655f
C2038 a_12403_43487# a_12790_43377# 0.01914f
C2039 a_4365_42711# a_3811_42685# 0.04548f
C2040 halfN/xq1.A halfN/xq3.A 0.07914f
C2041 VDPWR halfP/obuf6.A 0.70786f
C2042 a_17762_42167# uo_out[2] 0.01272f
C2043 uio_oe[7] tie_oe7.LO 0.04342f
C2044 a_25671_42141# a_25671_41891# 0.01302f
C2045 VDPWR halfN/RIN.R2_1 0.85961f
C2046 a_3811_41297# a_3811_40509# 0.01911f
C2047 halfP/xq0.A a_16495_41623# 0.20393f
C2048 a_4365_40535# a_4018_40509# 0.02068f
C2049 a_18355_42141# a_18187_42167# 0.20625f
C2050 VDPWR a_4365_42711# 0.05353f
C2051 a_13427_41597# a_13047_41775# 0.02545f
C2052 tie_oe6.LO VDPWR 0.30061f
C2053 halfN/dff4.D a_13434_41897# 0.05852f
C2054 a_10674_43377# a_10874_43532# 0.07623f
C2055 halfP/xq0.A a_16106_43255# 0.02203f
C2056 a_25078_43077# a_24639_42711# 0.16041f
C2057 halfP/dff4.D a_17086_39596# 0.01219f
C2058 halfP/CM1.C2 rst_n 0.54532f
C2059 a_26369_41079# a_26119_41079# 0.01818f
C2060 a_25671_39965# a_25671_40803# 0.01257f
C2061 a_19300_24748# VDPWR 7.65026f
C2062 a_15833_43261# a_16274_43229# 0.08347f
C2063 a_3818_42985# a_3818_42289# 0.01361f
C2064 halfN/RDA.R2_26 halfN/xq4.X 0.15213f
C2065 clk a_16955_42711# 0.01814f
C2066 a_15306_39570# halfP/dff6.D 0.1277f
C2067 halfP/dff1.D a_17493_41623# 0.08245f
C2068 a_3811_43473# a_3818_43377# 0.56916f
C2069 rst_n RBT.R1_0 0.04898f
C2070 halfP/RIN.R2_1 halfP/RDA.R2_4 0.16817f
C2071 clk halfN/xq2.A 0.34803f
C2072 VDPWR a_10287_43487# 0.31561f
C2073 a_25503_42167# VDPWR 0.15812f
C2074 uio_out[3] uio_out[2] 0.18241f
C2075 a_13434_41897# a_13047_41775# 0.01914f
C2076 halfP/xq3.A a_25078_41989# 0.01601f
C2077 VDPWR a_12959_42399# 0.16233f
C2078 VDPWR a_11447_41623# 0.14524f
C2079 a_15373_42173# a_15561_42167# 0.06685f
C2080 halfP/RIN.R2_1 ua[1] 0.02055f
C2081 clk halfN/dff5.D 0.02239f
C2082 a_13250_42289# a_12863_42399# 0.01914f
C2083 a_17139_43255# halfP/xq1.A 0.22401f
C2084 a_3811_41597# a_4365_41623# 0.04548f
C2085 a_24805_41623# a_24805_41085# 0.01361f
C2086 a_26119_43255# halfP/xq0.X 0.1188f
C2087 halfN/xq3.X halfN/xq4.X 3.75467f
C2088 a_12499_43487# halfN/xq3.A 0.02445f
C2089 halfN/dff3.D a_9954_39096# 0.08266f
C2090 a_4365_43633# a_3818_43377# 0.06685f
C2091 halfN/obuf6.A a_4365_41457# 0.08699f
C2092 uio_oe[4] halfN/xq0.A 0.01635f
C2093 VDPWR a_3818_41897# 0.25972f
C2094 a_25671_42141# a_25671_42979# 0.01257f
C2095 halfP/xq0.A a_25078_43255# 0.01584f
C2096 halfP/RIN.R2_1 halfP/xq5.X 0.24612f
C2097 a_18222_43255# a_18137_43255# 0.02068f
C2098 a_3527_40223# a_3431_40223# 0.20625f
C2099 a_3818_42289# a_3431_42399# 0.01914f
C2100 a_18187_42167# halfP/dff5.D 0.01082f
C2101 a_11318_41897# a_11447_41623# 0.08347f
C2102 a_12683_42685# a_12587_42863# 0.20625f
C2103 VDPWR a_9767_43229# 0.30709f
C2104 VDPWR halfN/xq4.X 0.41123f
C2105 a_3811_41297# halfN/obuf3.A 0.01218f
C2106 clk a_24639_42711# 0.15601f
C2107 halfN/xq2.X halfN/xq2.B 0.01332f
C2108 clk uio_out[5] 0.20499f
C2109 tie_oe0.LO VDPWR 0.31269f
C2110 uio_oe[0] halfN/xq1.A 0.0631f
C2111 a_24805_41085# a_25503_41079# 0.1112f
C2112 halfN/xq5.B a_3431_40687# 0.07523f
C2113 clk uio_oe[7] 0.17056f
C2114 halfN/mon.A uio_out[0] 0.01357f
C2115 VDPWR a_24993_43255# 0.05353f
C2116 halfN/xq4.B VDPWR 0.22607f
C2117 VDPWR a_26119_42961# 0.14245f
C2118 uo_out[6] uio_out[1] 0.03336f
C2119 halfN/dff2.D uio_out[1] 0.05735f
C2120 VDPWR a_17762_42167# 0.19813f
C2121 a_17762_42167# a_17323_42173# 0.16041f
C2122 ua[2] VGND 0.14723f
C2123 ua[3] VGND 0.14723f
C2124 ua[4] VGND 0.14723f
C2125 ua[5] VGND 0.14723f
C2126 ua[6] VGND 0.14723f
C2127 ua[7] VGND 0.14723f
C2128 ena VGND 0.07059f
C2129 ui_in[0] VGND 0.04273f
C2130 ui_in[1] VGND 0.04273f
C2131 ui_in[2] VGND 0.04204f
C2132 ui_in[3] VGND 0.04209f
C2133 ui_in[4] VGND 0.04214f
C2134 ui_in[5] VGND 0.04227f
C2135 ui_in[6] VGND 0.04219f
C2136 ui_in[7] VGND 0.04136f
C2137 uio_in[0] VGND 0.04076f
C2138 uio_in[1] VGND 0.04076f
C2139 uio_in[2] VGND 0.04091f
C2140 uio_in[3] VGND 0.04091f
C2141 uio_in[4] VGND 0.04091f
C2142 uio_in[5] VGND 0.04091f
C2143 uio_in[6] VGND 0.04091f
C2144 uio_in[7] VGND 0.04026f
C2145 ua[0] VGND 13.149f
C2146 ua[1] VGND 20.791f
C2147 uo_out[2] VGND 0.83061f
C2148 uo_out[6] VGND 0.65098f
C2149 uio_out[1] VGND 1.58945f
C2150 uio_out[5] VGND 1.26426f
C2151 uo_out[1] VGND 0.91708f
C2152 uo_out[5] VGND 0.63966f
C2153 uio_out[2] VGND 0.59711f
C2154 uio_out[6] VGND 0.89471f
C2155 uo_out[4] VGND 0.58376f
C2156 uo_out[7] VGND 1.34692f
C2157 uio_out[0] VGND 1.34692f
C2158 uio_out[3] VGND 0.58376f
C2159 uio_oe[0] VGND 0.95424f
C2160 uio_oe[2] VGND 0.60613f
C2161 uio_oe[4] VGND 0.53831f
C2162 uio_oe[6] VGND 0.73513f
C2163 uo_out[0] VGND 0.96358f
C2164 uo_out[3] VGND 0.96304f
C2165 uio_out[4] VGND 0.53945f
C2166 uio_out[7] VGND 0.87579f
C2167 uio_oe[1] VGND 0.63495f
C2168 uio_oe[3] VGND 0.57016f
C2169 uio_oe[5] VGND 0.51603f
C2170 uio_oe[7] VGND 1.00529f
C2171 VDPWR VGND 0.44229p
C2172 RBT.R1_6 VGND 0.53702f
C2173 RBT.R2_5 VGND 0.51821f
C2174 RBT.R1_4 VGND 0.36853f
C2175 RBT.R2_3 VGND 0.36133f
C2176 RBT.R1_2 VGND 0.36853f
C2177 RBT.R2_1 VGND 0.3604f
C2178 RBT.R1_0 VGND 0.48215f
C2179 RT.R1_6 VGND 0.48215f
C2180 RT.R2_5 VGND 0.35998f
C2181 RT.R1_4 VGND 0.36853f
C2182 RT.R2_3 VGND 0.36027f
C2183 RT.R1_2 VGND 0.36853f
C2184 RT.R2_1 VGND 0.36002f
C2185 RT.R1_0 VGND 0.53411f
C2186 RB.R1_0 VGND 0.69833f
C2187 a_24244_26120# VGND 0.10467f
C2188 a_17026_24748# VGND 26.46266f
C2189 a_5130_26120# VGND 11.70557f
C2190 a_5356_24748# VGND 11.97012f
C2191 a_24310_24722# VGND 68.11303f
C2192 a_3464_26480# VGND 16.26751f
C2193 halfP/RDA.R1_43 VGND 0.33547f
C2194 halfP/RDA.R1_41 VGND 0.37999f
C2195 halfP/RDA.R2_40 VGND 0.37999f
C2196 halfP/RDA.R1_39 VGND 0.37999f
C2197 halfP/RDA.R2_38 VGND 0.37977f
C2198 halfP/RDA.R1_37 VGND 0.37999f
C2199 halfP/RDA.R1_35 VGND 0.37999f
C2200 halfP/RDA.R2_34 VGND 0.37999f
C2201 halfP/RDA.R1_33 VGND 0.37999f
C2202 halfP/RDA.R2_32 VGND 0.37999f
C2203 halfP/RDA.R1_31 VGND 0.37999f
C2204 halfP/RDA.R1_29 VGND 0.37988f
C2205 halfP/RDA.R2_28 VGND 0.37999f
C2206 halfP/RDA.R1_27 VGND 0.37999f
C2207 halfP/RDA.R2_26 VGND 0.37999f
C2208 halfP/RDA.R1_25 VGND 0.37999f
C2209 halfP/RDA.R1_23 VGND 0.37999f
C2210 halfP/RDA.R2_22 VGND 0.37999f
C2211 halfP/RDA.R1_21 VGND 0.38021f
C2212 halfP/RDA.R2_20 VGND 0.37999f
C2213 halfP/RDA.R1_19 VGND 0.37999f
C2214 halfP/RDA.R1_17 VGND 0.39541f
C2215 halfP/RDA.R2_16 VGND 0.37999f
C2216 halfP/RDA.R1_15 VGND 0.37727f
C2217 halfP/RDA.R2_14 VGND 0.37999f
C2218 halfP/RDA.R1_13 VGND 0.37499f
C2219 halfP/RDA.R1_11 VGND 0.37704f
C2220 halfP/RDA.R2_10 VGND 0.37999f
C2221 halfP/RDA.R1_9 VGND 0.3755f
C2222 halfP/RDA.R2_8 VGND 0.37999f
C2223 halfP/RDA.R1_7 VGND 0.3763f
C2224 halfP/RDA.R1_5 VGND 0.37399f
C2225 halfP/RDA.R2_4 VGND 0.37977f
C2226 halfP/RDA.R1_3 VGND 0.3768f
C2227 halfP/RDA.R2_2 VGND 0.37999f
C2228 halfP/RDA.R1_1 VGND 0.37596f
C2229 halfP/RDA.R1_0 VGND 0.33399f
C2230 halfP/RIN.R1_0 VGND 0.69463f
C2231 halfN/RIN.R1_0 VGND 0.69463f
C2232 RARR.R2_2 VGND 0.37983f
C2233 RARR.R2_1 VGND 0.87792f
C2234 halfN/RDA.R1_0 VGND 0.33399f
C2235 halfN/RDA.R1_1 VGND 0.37593f
C2236 halfN/RDA.R2_2 VGND 0.37999f
C2237 halfN/RDA.R1_3 VGND 0.3768f
C2238 halfN/RDA.R2_4 VGND 0.37977f
C2239 halfN/RDA.R1_5 VGND 0.37399f
C2240 halfN/RDA.R1_7 VGND 0.3763f
C2241 halfN/RDA.R2_8 VGND 0.37999f
C2242 halfN/RDA.R1_9 VGND 0.3755f
C2243 halfN/RDA.R2_10 VGND 0.37999f
C2244 halfN/RDA.R1_11 VGND 0.37704f
C2245 halfN/RDA.R1_13 VGND 0.37499f
C2246 halfN/RDA.R2_14 VGND 0.37999f
C2247 halfN/RDA.R1_15 VGND 0.37727f
C2248 halfN/RDA.R2_16 VGND 0.37999f
C2249 halfN/RDA.R1_17 VGND 0.39541f
C2250 halfN/RDA.R1_19 VGND 0.37999f
C2251 halfN/RDA.R2_20 VGND 0.37999f
C2252 halfN/RDA.R1_21 VGND 0.38021f
C2253 halfN/RDA.R2_22 VGND 0.37999f
C2254 halfN/RDA.R1_23 VGND 0.37999f
C2255 halfN/RDA.R1_25 VGND 0.37999f
C2256 halfN/RDA.R2_26 VGND 0.37999f
C2257 halfN/RDA.R1_27 VGND 0.37999f
C2258 halfN/RDA.R2_28 VGND 0.37999f
C2259 halfN/RDA.R1_29 VGND 0.37988f
C2260 halfN/RDA.R1_31 VGND 0.37999f
C2261 halfN/RDA.R2_32 VGND 0.37999f
C2262 halfN/RDA.R1_33 VGND 0.37999f
C2263 halfN/RDA.R2_34 VGND 0.37999f
C2264 halfN/RDA.R1_35 VGND 0.37999f
C2265 halfN/RDA.R1_37 VGND 0.37999f
C2266 halfN/RDA.R2_38 VGND 0.37977f
C2267 halfN/RDA.R1_39 VGND 0.37999f
C2268 halfN/RDA.R2_40 VGND 0.37999f
C2269 halfN/RDA.R1_41 VGND 0.37999f
C2270 halfN/RDA.R1_43 VGND 0.33547f
C2271 RARR.R1_3 VGND 17.45937f
C2272 a_19486_39236# VGND 1.73389f
C2273 a_19006_39236# VGND 1.21519f
C2274 a_17086_39236# VGND 2.08349f
C2275 a_16606_39236# VGND 4.0727f
C2276 a_18046_39596# VGND 0.63184f
C2277 a_26369_39991# VGND 0.06981f
C2278 a_25587_39991# VGND 0.17172f
C2279 halfP/xq6.X VGND 5.12269f
C2280 a_26369_40311# VGND 1.89776f
C2281 RARR.R1_1 VGND 21.59815f
C2282 a_12294_39236# VGND 5.12005f
C2283 a_11334_39236# VGND 1.03898f
C2284 a_10854_39236# VGND 1.62514f
C2285 a_9894_39236# VGND 3.20801f
C2286 a_11814_39596# VGND 0.63184f
C2287 a_10374_39596# VGND 0.81214f
C2288 a_25204_40369# VGND 0.33334f
C2289 a_24993_39991# VGND 0.04915f
C2290 a_4365_40369# VGND 1.77416f
C2291 a_4167_40357# VGND 0.42953f
C2292 a_3017_40311# VGND 0.12151f
C2293 halfN/xq6.X VGND 5.23351f
C2294 a_26369_40535# VGND 0.11919f
C2295 a_25629_40535# VGND 0.12667f
C2296 halfP/xq5.X VGND 2.96896f
C2297 a_25204_40535# VGND 0.09624f
C2298 a_25587_40901# VGND 0.23826f
C2299 a_24993_40535# VGND 0.04915f
C2300 a_4167_40535# VGND 0.24599f
C2301 a_3746_40535# VGND 0.12667f
C2302 a_26119_40785# VGND 0.05389f
C2303 a_25246_40647# VGND 0.0709f
C2304 a_4365_40535# VGND 0.11248f
C2305 a_4194_40901# VGND 0.18301f
C2306 a_3769_40901# VGND 0.04872f
C2307 a_3185_40785# VGND 0.02669f
C2308 a_2829_40785# VGND 0.627f
C2309 halfN/xq5.X VGND 2.89152f
C2310 a_26369_41079# VGND 0.70002f
C2311 halfP/xq4.X VGND 2.7491f
C2312 a_26369_41399# VGND 0.11919f
C2313 a_4194_41079# VGND 0.34211f
C2314 a_25204_41457# VGND 0.22174f
C2315 a_24993_41079# VGND 0.19694f
C2316 a_4365_41457# VGND 0.04915f
C2317 a_3746_41445# VGND 0.12667f
C2318 a_3017_41399# VGND 0.11919f
C2319 halfN/xq4.X VGND 2.75487f
C2320 a_25246_41053# VGND 0.11892f
C2321 a_3947_41457# VGND 0.16096f
C2322 a_3431_41311# VGND 0.17052f
C2323 halfP/xq3.X VGND 2.42752f
C2324 a_26369_41873# VGND 0.06585f
C2325 a_26201_41873# VGND 0.89631f
C2326 a_25587_41989# VGND 0.04872f
C2327 a_18129_41623# VGND 0.19564f
C2328 a_25173_41989# VGND 0.20553f
C2329 a_24993_41623# VGND 0.37706f
C2330 a_18087_41989# VGND 0.12763f
C2331 a_17673_41989# VGND 0.20741f
C2332 a_17493_41623# VGND 0.04915f
C2333 a_15588_41623# VGND 0.10033f
C2334 a_15971_41989# VGND 0.36417f
C2335 a_15557_41989# VGND 0.0378f
C2336 a_15377_41623# VGND 0.04915f
C2337 a_13783_41623# VGND 0.21542f
C2338 a_13981_41623# VGND 0.14465f
C2339 a_13810_41989# VGND 0.02387f
C2340 a_11667_41623# VGND 0.13301f
C2341 a_11865_41623# VGND 0.04915f
C2342 a_11694_41989# VGND 0.32009f
C2343 a_4167_41623# VGND 0.09624f
C2344 a_3017_41623# VGND 0.09253f
C2345 a_4365_41623# VGND 0.04915f
C2346 a_4194_41989# VGND 0.03545f
C2347 a_3769_41989# VGND 0.40764f
C2348 a_3185_41873# VGND 1.01728f
C2349 a_2829_41873# VGND 0.18336f
C2350 halfN/xq3.X VGND 2.42929f
C2351 a_3527_41597# VGND 0.23785f
C2352 a_26369_42167# VGND 1.11757f
C2353 a_25587_42167# VGND 0.12148f
C2354 halfP/xq2.X VGND 2.33771f
C2355 a_18271_42167# VGND 0.15341f
C2356 a_25204_42545# VGND 0.20558f
C2357 a_24993_42167# VGND 3.41026f
C2358 a_15741_42167# VGND 0.09309f
C2359 a_17888_42545# VGND 0.23084f
C2360 a_17677_42167# VGND 0.04915f
C2361 a_16197_42545# VGND 0.05215f
C2362 a_13626_42167# VGND 0.27735f
C2363 a_15772_42545# VGND 0.25075f
C2364 a_15561_42167# VGND 1.15265f
C2365 a_13797_42545# VGND 0.04915f
C2366 a_13599_42533# VGND 0.28017f
C2367 a_11510_42167# VGND 0.27867f
C2368 a_11681_42545# VGND 0.04915f
C2369 a_11483_42533# VGND 0.16114f
C2370 a_4194_42167# VGND 0.03545f
C2371 a_4365_42545# VGND 0.287f
C2372 a_4167_42533# VGND 0.09624f
C2373 a_3185_42167# VGND 0.11284f
C2374 a_2829_42167# VGND 0.29193f
C2375 a_3746_42533# VGND 0.17498f
C2376 halfN/xq2.X VGND 2.30356f
C2377 a_25246_42141# VGND 1.68055f
C2378 a_18187_42167# VGND 0.18611f
C2379 a_15814_42141# VGND 0.1481f
C2380 a_11263_42545# VGND 0.24374f
C2381 a_4018_42444# VGND 0.23785f
C2382 a_25629_42711# VGND 0.18572f
C2383 halfP/xq1.X VGND 2.52461f
C2384 a_26369_42961# VGND 0.2485f
C2385 a_26201_42961# VGND 0.11284f
C2386 a_25204_42711# VGND 0.20558f
C2387 a_16473_42711# VGND 0.1899f
C2388 a_24993_42711# VGND 0.04915f
C2389 a_16431_43077# VGND 0.04933f
C2390 a_16017_43077# VGND 0.20246f
C2391 a_15837_42711# VGND 0.04915f
C2392 a_13323_42711# VGND 0.2498f
C2393 a_12902_42711# VGND 0.1899f
C2394 a_13521_42711# VGND 1.26013f
C2395 a_13350_43077# VGND 0.07446f
C2396 a_12925_43077# VGND 0.09541f
C2397 tie_oe0.LO VGND 0.09161f
C2398 tie_oe2.LO VGND 0.04997f
C2399 tie_oe4.LO VGND 0.04997f
C2400 tie_oe6.LO VGND 0.04997f
C2401 a_4167_42711# VGND 0.13169f
C2402 a_3746_42711# VGND 0.18572f
C2403 a_4365_42711# VGND 0.19694f
C2404 a_4194_43077# VGND 0.03695f
C2405 a_3769_43077# VGND 0.09375f
C2406 a_3185_42961# VGND 0.08991f
C2407 a_2829_42961# VGND 1.15538f
C2408 halfN/xq1.X VGND 2.43846f
C2409 a_26369_43255# VGND 0.40442f
C2410 a_26201_43255# VGND 1.79332f
C2411 a_25587_43255# VGND 0.15665f
C2412 a_25173_43255# VGND 0.18848f
C2413 halfP/xq0.X VGND 5.23575f
C2414 a_18731_43255# VGND 0.13551f
C2415 a_18317_43255# VGND 0.21551f
C2416 a_25204_43633# VGND 0.04571f
C2417 a_24993_43255# VGND 0.04915f
C2418 a_18773_43633# VGND 0.20467f
C2419 a_16615_43255# VGND 0.22628f
C2420 a_18137_43255# VGND 2.75096f
C2421 a_13166_43255# VGND 0.36193f
C2422 a_16232_43633# VGND 0.27365f
C2423 a_16021_43255# VGND 1.36702f
C2424 a_13337_43633# VGND 1.21162f
C2425 a_13139_43621# VGND 0.16353f
C2426 a_11050_43255# VGND 0.09532f
C2427 a_11221_43633# VGND 2.80861f
C2428 tie_oe1.LO VGND 0.07805f
C2429 a_25503_43255# VGND 0.3487f
C2430 a_12919_43633# VGND 0.09642f
C2431 a_10803_43633# VGND 0.25923f
C2432 tie_oe3.LO VGND 0.04998f
C2433 tie_oe5.LO VGND 0.04998f
C2434 tie_oe7.LO VGND 0.04998f
C2435 a_4194_43255# VGND 0.2847f
C2436 a_4365_43633# VGND 0.09406f
C2437 a_4167_43621# VGND 0.16438f
C2438 a_3185_43255# VGND 0.1283f
C2439 a_2829_43255# VGND 0.28381f
C2440 a_3746_43621# VGND 0.05662f
C2441 halfN/xq0.X VGND 5.27492f
C2442 a_3947_43633# VGND 0.2495f
.ends
