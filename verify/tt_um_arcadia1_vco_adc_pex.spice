* NGSPICE file created from tt_um_arcadia1_vco_adc.ext - technology: sky130A

.subckt sky130_fd_pr__res_xhigh_po_0p35_4MFQX6 R1_4 R1_3 R1_2 R1_1 R1_0 B R2_7 R2_6
+ R2_5 R2_4 R2_3 R2_2 R2_1 R2_0 R1_7 R1_6 R1_5
X0 R1_0 R2_0 B sky130_fd_pr__res_xhigh_po_0p35 l=4.38
X1 R1_6 R2_6 B sky130_fd_pr__res_xhigh_po_0p35 l=4.38
X2 R1_7 R2_7 B sky130_fd_pr__res_xhigh_po_0p35 l=4.38
X3 R1_5 R2_5 B sky130_fd_pr__res_xhigh_po_0p35 l=4.38
X4 R1_2 R2_2 B sky130_fd_pr__res_xhigh_po_0p35 l=4.38
X5 R1_4 R2_4 B sky130_fd_pr__res_xhigh_po_0p35 l=4.38
X6 R1_1 R2_1 B sky130_fd_pr__res_xhigh_po_0p35 l=4.38
X7 R1_3 R2_3 B sky130_fd_pr__res_xhigh_po_0p35 l=4.38
C0 R1_4 R1_3 0.29626f
C1 R2_4 R2_3 0.29626f
C2 R2_7 R2_6 0.29626f
C3 R1_4 R1_5 0.29626f
C4 R1_2 R1_3 0.29626f
C5 R1_2 R1_1 0.29626f
C6 R1_7 R1_6 0.29626f
C7 R2_0 R2_1 0.29626f
C8 R2_6 R2_5 0.29626f
C9 R2_2 R2_3 0.29626f
C10 R1_6 R1_5 0.29626f
C11 R2_2 R2_1 0.29626f
C12 R1_1 R1_0 0.29626f
C13 R2_4 R2_5 0.29626f
C14 R2_7 B 0.39525f
C15 R1_7 B 0.39525f
C16 R2_6 B 0.17336f
C17 R1_6 B 0.17336f
C18 R2_5 B 0.17325f
C19 R1_5 B 0.17325f
C20 R2_4 B 0.17336f
C21 R1_4 B 0.17336f
C22 R2_3 B 0.17336f
C23 R1_3 B 0.17336f
C24 R2_2 B 0.17325f
C25 R1_2 B 0.17325f
C26 R2_1 B 0.17336f
C27 R1_1 B 0.17336f
C28 R2_0 B 0.39525f
C29 R1_0 B 0.39525f
.ends

.subckt sky130_fd_pr__res_xhigh_po_0p35_JUTA22 R1_4 R1_3 R1_2 R1_1 R1_0 B R2_5 R2_4
+ R2_3 R2_2 R2_1 R2_0 R1_5
X0 R1_0 R2_0 B sky130_fd_pr__res_xhigh_po_0p35 l=30
X1 R1_1 R2_1 B sky130_fd_pr__res_xhigh_po_0p35 l=30
X2 R1_3 R2_3 B sky130_fd_pr__res_xhigh_po_0p35 l=30
X3 R1_4 R2_4 B sky130_fd_pr__res_xhigh_po_0p35 l=30
X4 R1_2 R2_2 B sky130_fd_pr__res_xhigh_po_0p35 l=30
X5 R1_5 R2_5 B sky130_fd_pr__res_xhigh_po_0p35 l=30
C0 R1_2 R1_1 0.29626f
C1 R2_1 R2_2 0.29626f
C2 R1_4 R1_3 0.29626f
C3 R2_1 R2_0 0.29626f
C4 R2_2 R2_3 0.29626f
C5 R1_1 R1_0 0.29626f
C6 R1_2 R1_3 0.29626f
C7 R2_4 R2_3 0.29626f
C8 R1_5 R1_4 0.29626f
C9 R2_5 R2_4 0.29626f
C10 R2_5 B 0.40066f
C11 R1_5 B 0.40066f
C12 R2_4 B 0.17894f
C13 R1_4 B 0.17894f
C14 R2_3 B 0.17883f
C15 R1_3 B 0.17883f
C16 R2_2 B 0.17883f
C17 R1_2 B 0.17883f
C18 R2_1 B 0.17894f
C19 R1_1 B 0.17894f
C20 R2_0 B 0.40066f
C21 R1_0 B 0.40066f
.ends

.subckt sky130_fd_pr__res_xhigh_po_0p35_V6BCNG R1_3 R1_2 R1_1 R1_0 B R2_3 R2_2 R2_1
+ R2_0
X0 R1_1 R2_1 B sky130_fd_pr__res_xhigh_po_0p35 l=3.25
X1 R1_3 R2_3 B sky130_fd_pr__res_xhigh_po_0p35 l=3.25
X2 R1_0 R2_0 B sky130_fd_pr__res_xhigh_po_0p35 l=3.25
X3 R1_2 R2_2 B sky130_fd_pr__res_xhigh_po_0p35 l=3.25
C0 R2_1 R2_2 0.29626f
C1 R1_1 R1_2 0.29626f
C2 R1_2 R1_3 0.29626f
C3 R1_1 R1_0 0.29626f
C4 R2_1 R2_0 0.29626f
C5 R2_2 R2_3 0.29626f
C6 R2_3 B 0.39412f
C7 R1_3 B 0.39412f
C8 R2_2 B 0.17161f
C9 R1_2 B 0.17161f
C10 R2_1 B 0.17161f
C11 R1_1 B 0.17161f
C12 R2_0 B 0.39412f
C13 R1_0 B 0.39412f
.ends

.subckt sky130_fd_sc_hd__xor2_1 VNB VPB VPWR VGND A X B a_285_297# a_35_297#
X0 X a_35_297# a_285_297# VPB sky130_fd_pr__pfet_01v8_hvt ad=0.3 pd=2.6 as=0.26 ps=2.52 w=1 l=0.15
X1 X B a_285_47# VNB sky130_fd_pr__nfet_01v8 ad=0.25025 pd=1.42 as=0.08775 ps=0.92 w=0.65 l=0.15
X2 a_35_297# B VGND VNB sky130_fd_pr__nfet_01v8 ad=0.08775 pd=0.92 as=0.169 ps=1.82 w=0.65 l=0.15
X3 a_117_297# B a_35_297# VPB sky130_fd_pr__pfet_01v8_hvt ad=0.135 pd=1.27 as=0.26 ps=2.52 w=1 l=0.15
X4 VPWR B a_285_297# VPB sky130_fd_pr__pfet_01v8_hvt ad=0.26 pd=2.52 as=0.135 ps=1.27 w=1 l=0.15
X5 VGND A a_35_297# VNB sky130_fd_pr__nfet_01v8 ad=0.08775 pd=0.92 as=0.08775 ps=0.92 w=0.65 l=0.15
X6 VGND a_35_297# X VNB sky130_fd_pr__nfet_01v8 ad=0.208 pd=1.94 as=0.25025 ps=1.42 w=0.65 l=0.15
X7 a_285_297# A VPWR VPB sky130_fd_pr__pfet_01v8_hvt ad=0.135 pd=1.27 as=0.135 ps=1.27 w=1 l=0.15
X8 VPWR A a_117_297# VPB sky130_fd_pr__pfet_01v8_hvt ad=0.135 pd=1.27 as=0.135 ps=1.27 w=1 l=0.15
X9 a_285_47# A VGND VNB sky130_fd_pr__nfet_01v8 ad=0.08775 pd=0.92 as=0.08775 ps=0.92 w=0.65 l=0.15
C0 VPWR VPB 0.06891f
C1 VPWR A 0.03484f
C2 a_35_297# X 0.166f
C3 VGND B 0.03045f
C4 VPWR X 0.05365f
C5 VPWR a_35_297# 0.09604f
C6 a_285_297# VPB 0.01327f
C7 a_285_297# X 0.07125f
C8 a_35_297# a_285_297# 0.02504f
C9 VPWR a_285_297# 0.24631f
C10 VGND A 0.03254f
C11 VGND X 0.1729f
C12 VGND a_35_297# 0.17666f
C13 VPB B 0.06969f
C14 VGND VPWR 0.06426f
C15 A B 0.22134f
C16 X B 0.01488f
C17 a_35_297# B 0.203f
C18 VPWR B 0.07031f
C19 A VPB 0.05101f
C20 a_285_297# B 0.05532f
C21 VPB X 0.01541f
C22 a_35_297# VPB 0.06993f
C23 a_35_297# A 0.06334f
C24 VGND VNB 0.43488f
C25 X VNB 0.06491f
C26 VPWR VNB 0.33278f
C27 A VNB 0.16672f
C28 B VNB 0.21337f
C29 VPB VNB 0.69336f
C30 a_35_297# VNB 0.25457f
.ends

.subckt sky130_fd_sc_hd__dfxtp_4 VGND VPWR VNB VPB Q D CLK a_891_413# a_193_47# a_381_47#
+ a_1062_300# a_475_413# a_634_183# a_27_47#
X0 Q a_1062_300# VPWR VPB sky130_fd_pr__pfet_01v8_hvt ad=0.135 pd=1.27 as=0.1425 ps=1.285 w=1 l=0.15
X1 a_1020_47# a_27_47# a_891_413# VNB sky130_fd_pr__special_nfet_01v8 ad=0.066 pd=0.745 as=0.0657 ps=0.725 w=0.36 l=0.15
X2 a_572_47# a_193_47# a_475_413# VNB sky130_fd_pr__special_nfet_01v8 ad=0.0687 pd=0.76 as=0.0594 ps=0.69 w=0.36 l=0.15
X3 VPWR a_1062_300# a_975_413# VPB sky130_fd_pr__pfet_01v8_hvt ad=0.1218 pd=1.42 as=0.09135 ps=0.855 w=0.42 l=0.15
X4 a_634_183# a_475_413# VGND VNB sky130_fd_pr__nfet_01v8 ad=0.0989 pd=0.995 as=0.1493 ps=1.22 w=0.64 l=0.15
X5 VPWR CLK a_27_47# VPB sky130_fd_pr__pfet_01v8_hvt ad=0.0864 pd=0.91 as=0.1664 ps=1.8 w=0.64 l=0.15
X6 a_381_47# D VPWR VPB sky130_fd_pr__pfet_01v8_hvt ad=0.0672 pd=0.74 as=0.1092 ps=1.36 w=0.42 l=0.15
X7 a_475_413# a_27_47# a_381_47# VNB sky130_fd_pr__special_nfet_01v8 ad=0.0594 pd=0.69 as=0.066 ps=0.745 w=0.36 l=0.15
X8 VGND a_1062_300# a_1020_47# VNB sky130_fd_pr__nfet_01v8 ad=0.1197 pd=1.41 as=0.066 ps=0.745 w=0.42 l=0.15
X9 VPWR a_634_183# a_568_413# VPB sky130_fd_pr__pfet_01v8_hvt ad=0.17887 pd=1.26 as=0.0693 ps=0.75 w=0.42 l=0.15
X10 Q a_1062_300# VGND VNB sky130_fd_pr__nfet_01v8 ad=0.08775 pd=0.92 as=0.09262 ps=0.935 w=0.65 l=0.15
X11 a_568_413# a_27_47# a_475_413# VPB sky130_fd_pr__pfet_01v8_hvt ad=0.0693 pd=0.75 as=0.06615 ps=0.735 w=0.42 l=0.15
X12 a_634_183# a_475_413# VPWR VPB sky130_fd_pr__pfet_01v8_hvt ad=0.1095 pd=1.075 as=0.17887 ps=1.26 w=0.75 l=0.15
X13 a_975_413# a_193_47# a_891_413# VPB sky130_fd_pr__pfet_01v8_hvt ad=0.09135 pd=0.855 as=0.0567 ps=0.69 w=0.42 l=0.15
X14 a_193_47# a_27_47# VGND VNB sky130_fd_pr__nfet_01v8 ad=0.1092 pd=1.36 as=0.0567 ps=0.69 w=0.42 l=0.15
X15 a_891_413# a_27_47# a_634_183# VPB sky130_fd_pr__pfet_01v8_hvt ad=0.0567 pd=0.69 as=0.1095 ps=1.075 w=0.42 l=0.15
X16 Q a_1062_300# VGND VNB sky130_fd_pr__nfet_01v8 ad=0.08775 pd=0.92 as=0.10563 ps=0.975 w=0.65 l=0.15
X17 VGND a_891_413# a_1062_300# VNB sky130_fd_pr__nfet_01v8 ad=0.10563 pd=0.975 as=0.169 ps=1.82 w=0.65 l=0.15
X18 VPWR a_1062_300# Q VPB sky130_fd_pr__pfet_01v8_hvt ad=0.1425 pd=1.285 as=0.135 ps=1.27 w=1 l=0.15
X19 VGND a_1062_300# Q VNB sky130_fd_pr__nfet_01v8 ad=0.18525 pd=1.87 as=0.08775 ps=0.92 w=0.65 l=0.15
X20 Q a_1062_300# VPWR VPB sky130_fd_pr__pfet_01v8_hvt ad=0.135 pd=1.27 as=0.1625 ps=1.325 w=1 l=0.15
X21 a_193_47# a_27_47# VPWR VPB sky130_fd_pr__pfet_01v8_hvt ad=0.1664 pd=1.8 as=0.0864 ps=0.91 w=0.64 l=0.15
X22 VGND a_1062_300# Q VNB sky130_fd_pr__nfet_01v8 ad=0.09262 pd=0.935 as=0.08775 ps=0.92 w=0.65 l=0.15
X23 a_381_47# D VGND VNB sky130_fd_pr__nfet_01v8 ad=0.066 pd=0.745 as=0.1092 ps=1.36 w=0.42 l=0.15
X24 VPWR a_891_413# a_1062_300# VPB sky130_fd_pr__pfet_01v8_hvt ad=0.1625 pd=1.325 as=0.28 ps=2.56 w=1 l=0.15
X25 a_475_413# a_193_47# a_381_47# VPB sky130_fd_pr__pfet_01v8_hvt ad=0.06615 pd=0.735 as=0.0672 ps=0.74 w=0.42 l=0.15
X26 a_891_413# a_193_47# a_634_183# VNB sky130_fd_pr__special_nfet_01v8 ad=0.0657 pd=0.725 as=0.0989 ps=0.995 w=0.36 l=0.15
X27 VGND a_634_183# a_572_47# VNB sky130_fd_pr__nfet_01v8 ad=0.1493 pd=1.22 as=0.0687 ps=0.76 w=0.42 l=0.15
X28 VGND CLK a_27_47# VNB sky130_fd_pr__nfet_01v8 ad=0.0567 pd=0.69 as=0.1092 ps=1.36 w=0.42 l=0.15
X29 VPWR a_1062_300# Q VPB sky130_fd_pr__pfet_01v8_hvt ad=0.28 pd=2.56 as=0.135 ps=1.27 w=1 l=0.15
C0 VPWR VGND 0.10063f
C1 a_891_413# a_1062_300# 0.28549f
C2 VPWR a_27_47# 0.3831f
C3 a_1062_300# VPB 0.24732f
C4 VGND a_193_47# 0.30543f
C5 a_27_47# a_193_47# 0.72386f
C6 Q VPB 0.01336f
C7 a_27_47# VGND 0.12468f
C8 VPWR a_475_413# 0.16822f
C9 VPWR D 0.02726f
C10 a_475_413# a_193_47# 0.15754f
C11 D a_193_47# 0.10396f
C12 a_475_413# VGND 0.09216f
C13 VGND D 0.0264f
C14 VPWR a_891_413# 0.11394f
C15 a_27_47# a_475_413# 0.17844f
C16 VPWR VPB 0.19856f
C17 a_27_47# D 0.09699f
C18 a_381_47# VPWR 0.05338f
C19 a_891_413# a_193_47# 0.13928f
C20 a_193_47# VPB 0.14138f
C21 a_381_47# a_193_47# 0.16187f
C22 VGND a_891_413# 0.11673f
C23 VGND VPB 0.01466f
C24 a_27_47# a_891_413# 0.03777f
C25 a_27_47# VPB 0.27543f
C26 a_381_47# VGND 0.04483f
C27 a_634_183# VPWR 0.10209f
C28 a_381_47# a_27_47# 0.03397f
C29 a_634_183# a_193_47# 0.13099f
C30 Q a_1062_300# 0.38792f
C31 a_634_183# VGND 0.12391f
C32 a_634_183# a_27_47# 0.16612f
C33 a_475_413# VPB 0.07594f
C34 D VPB 0.09609f
C35 VPWR CLK 0.01941f
C36 a_381_47# a_475_413# 0.03564f
C37 a_381_47# D 0.07679f
C38 a_891_413# VPB 0.06876f
C39 VGND CLK 0.01946f
C40 VPWR a_1062_300# 0.22605f
C41 a_634_183# a_475_413# 0.24864f
C42 a_27_47# CLK 0.21376f
C43 a_381_47# VPB 0.01358f
C44 a_1062_300# a_193_47# 0.03024f
C45 Q VPWR 0.33578f
C46 VGND a_1062_300# 0.19483f
C47 a_634_183# a_891_413# 0.03548f
C48 a_27_47# a_1062_300# 0.04869f
C49 a_634_183# VPB 0.07362f
C50 Q VGND 0.24206f
C51 CLK VPB 0.07006f
C52 VPWR a_193_47# 0.10663f
C53 Q VNB 0.0608f
C54 VGND VNB 0.98893f
C55 VPWR VNB 0.82311f
C56 D VNB 0.12973f
C57 CLK VNB 0.19598f
C58 VPB VNB 1.75651f
C59 a_381_47# VNB 0.0164f
C60 a_891_413# VNB 0.16089f
C61 a_1062_300# VNB 0.52966f
C62 a_475_413# VNB 0.13718f
C63 a_634_183# VNB 0.15021f
C64 a_193_47# VNB 0.27118f
C65 a_27_47# VNB 0.4683f
.ends

.subckt sky130_fd_pr__res_xhigh_po_0p35_Y3K97R R1_1 R1_0 B R2_1 R2_0
X0 R1_1 R2_1 B sky130_fd_pr__res_xhigh_po_0p35 l=4.3
X1 R1_0 R2_0 B sky130_fd_pr__res_xhigh_po_0p35 l=4.3
C0 R2_0 R2_1 0.29626f
C1 R1_1 R1_0 0.29626f
C2 R2_1 B 0.39561f
C3 R1_1 B 0.39561f
C4 R2_0 B 0.39561f
C5 R1_0 B 0.39561f
.ends

.subckt sky130_fd_sc_hd__buf_4 VPWR VGND X A VPB VNB a_27_47#
X0 VPWR a_27_47# X VPB sky130_fd_pr__pfet_01v8_hvt ad=0.26 pd=2.52 as=0.135 ps=1.27 w=1 l=0.15
X1 X a_27_47# VPWR VPB sky130_fd_pr__pfet_01v8_hvt ad=0.135 pd=1.27 as=0.135 ps=1.27 w=1 l=0.15
X2 VPWR a_27_47# X VPB sky130_fd_pr__pfet_01v8_hvt ad=0.135 pd=1.27 as=0.135 ps=1.27 w=1 l=0.15
X3 X a_27_47# VPWR VPB sky130_fd_pr__pfet_01v8_hvt ad=0.135 pd=1.27 as=0.135 ps=1.27 w=1 l=0.15
X4 X a_27_47# VGND VNB sky130_fd_pr__nfet_01v8 ad=0.08775 pd=0.92 as=0.08775 ps=0.92 w=0.65 l=0.15
X5 X a_27_47# VGND VNB sky130_fd_pr__nfet_01v8 ad=0.08775 pd=0.92 as=0.08775 ps=0.92 w=0.65 l=0.15
X6 VGND a_27_47# X VNB sky130_fd_pr__nfet_01v8 ad=0.08775 pd=0.92 as=0.08775 ps=0.92 w=0.65 l=0.15
X7 VGND a_27_47# X VNB sky130_fd_pr__nfet_01v8 ad=0.169 pd=1.82 as=0.08775 ps=0.92 w=0.65 l=0.15
X8 VPWR A a_27_47# VPB sky130_fd_pr__pfet_01v8_hvt ad=0.135 pd=1.27 as=0.26 ps=2.52 w=1 l=0.15
X9 VGND A a_27_47# VNB sky130_fd_pr__nfet_01v8 ad=0.08775 pd=0.92 as=0.169 ps=1.82 w=0.65 l=0.15
C0 A VPWR 0.01601f
C1 X VGND 0.22989f
C2 X a_27_47# 0.20651f
C3 A VPB 0.03609f
C4 A VGND 0.01937f
C5 VPWR VPB 0.07107f
C6 A a_27_47# 0.17018f
C7 VPWR VGND 0.07203f
C8 VPWR a_27_47# 0.21812f
C9 VPB a_27_47# 0.13215f
C10 VGND a_27_47# 0.16264f
C11 X VPWR 0.33254f
C12 VGND VNB 0.37777f
C13 X VNB 0.03903f
C14 VPWR VNB 0.32508f
C15 A VNB 0.13997f
C16 VPB VNB 0.60476f
C17 a_27_47# VNB 0.46146f
.ends

.subckt sky130_fd_pr__cap_mim_m3_1_4SMZ5E C1 C2 VSUBS
X0 C1 C2 sky130_fd_pr__cap_mim_m3_1 l=25 w=24
C0 C1 C2 53.1086f
C1 C1 VSUBS 2.52332f
C2 C2 VSUBS 13.4166f
.ends

.subckt sky130_fd_sc_hd__dfxtp_1 Q CLK D VPB VNB VPWR VGND a_891_413# a_466_413# a_1059_315#
+ a_193_47# a_634_159# a_381_47# a_27_47#
X0 Q a_1059_315# VGND VNB sky130_fd_pr__nfet_01v8 ad=0.169 pd=1.82 as=0.08775 ps=0.92 w=0.65 l=0.15
X1 a_891_413# a_193_47# a_634_159# VNB sky130_fd_pr__special_nfet_01v8 ad=0.0684 pd=0.74 as=0.0989 ps=0.995 w=0.36 l=0.15
X2 a_561_413# a_27_47# a_466_413# VPB sky130_fd_pr__pfet_01v8_hvt ad=0.07665 pd=0.785 as=0.06825 ps=0.745 w=0.42 l=0.15
X3 VPWR CLK a_27_47# VPB sky130_fd_pr__pfet_01v8_hvt ad=0.0864 pd=0.91 as=0.1664 ps=1.8 w=0.64 l=0.15
X4 Q a_1059_315# VPWR VPB sky130_fd_pr__pfet_01v8_hvt ad=0.26 pd=2.52 as=0.135 ps=1.27 w=1 l=0.15
X5 a_381_47# D VPWR VPB sky130_fd_pr__pfet_01v8_hvt ad=0.05775 pd=0.695 as=0.1092 ps=1.36 w=0.42 l=0.15
X6 VGND a_634_159# a_592_47# VNB sky130_fd_pr__nfet_01v8 ad=0.12095 pd=1.085 as=0.0696 ps=0.765 w=0.42 l=0.15
X7 VPWR a_891_413# a_1059_315# VPB sky130_fd_pr__pfet_01v8_hvt ad=0.135 pd=1.27 as=0.27 ps=2.54 w=1 l=0.15
X8 a_466_413# a_193_47# a_381_47# VPB sky130_fd_pr__pfet_01v8_hvt ad=0.06825 pd=0.745 as=0.05775 ps=0.695 w=0.42 l=0.15
X9 VPWR a_634_159# a_561_413# VPB sky130_fd_pr__pfet_01v8_hvt ad=0.17887 pd=1.26 as=0.07665 ps=0.785 w=0.42 l=0.15
X10 a_634_159# a_466_413# VGND VNB sky130_fd_pr__nfet_01v8 ad=0.0989 pd=0.995 as=0.12095 ps=1.085 w=0.64 l=0.15
X11 a_634_159# a_466_413# VPWR VPB sky130_fd_pr__pfet_01v8_hvt ad=0.1095 pd=1.075 as=0.17887 ps=1.26 w=0.75 l=0.15
X12 a_975_413# a_193_47# a_891_413# VPB sky130_fd_pr__pfet_01v8_hvt ad=0.0882 pd=0.84 as=0.0567 ps=0.69 w=0.42 l=0.15
X13 VGND a_1059_315# a_1017_47# VNB sky130_fd_pr__nfet_01v8 ad=0.1092 pd=1.36 as=0.066 ps=0.745 w=0.42 l=0.15
X14 a_193_47# a_27_47# VGND VNB sky130_fd_pr__nfet_01v8 ad=0.1092 pd=1.36 as=0.0567 ps=0.69 w=0.42 l=0.15
X15 a_891_413# a_27_47# a_634_159# VPB sky130_fd_pr__pfet_01v8_hvt ad=0.0567 pd=0.69 as=0.1095 ps=1.075 w=0.42 l=0.15
X16 a_592_47# a_193_47# a_466_413# VNB sky130_fd_pr__special_nfet_01v8 ad=0.0696 pd=0.765 as=0.0621 ps=0.705 w=0.36 l=0.15
X17 VPWR a_1059_315# a_975_413# VPB sky130_fd_pr__pfet_01v8_hvt ad=0.1113 pd=1.37 as=0.0882 ps=0.84 w=0.42 l=0.15
X18 a_1017_47# a_27_47# a_891_413# VNB sky130_fd_pr__special_nfet_01v8 ad=0.066 pd=0.745 as=0.0684 ps=0.74 w=0.36 l=0.15
X19 a_193_47# a_27_47# VPWR VPB sky130_fd_pr__pfet_01v8_hvt ad=0.1664 pd=1.8 as=0.0864 ps=0.91 w=0.64 l=0.15
X20 a_466_413# a_27_47# a_381_47# VNB sky130_fd_pr__special_nfet_01v8 ad=0.0621 pd=0.705 as=0.0813 ps=0.83 w=0.36 l=0.15
X21 VGND a_891_413# a_1059_315# VNB sky130_fd_pr__nfet_01v8 ad=0.08775 pd=0.92 as=0.169 ps=1.82 w=0.65 l=0.15
X22 a_381_47# D VGND VNB sky130_fd_pr__nfet_01v8 ad=0.0813 pd=0.83 as=0.1092 ps=1.36 w=0.42 l=0.15
X23 VGND CLK a_27_47# VNB sky130_fd_pr__nfet_01v8 ad=0.0567 pd=0.69 as=0.1092 ps=1.36 w=0.42 l=0.15
C0 VPB Q 0.01383f
C1 a_891_413# VPWR 0.11532f
C2 a_891_413# a_634_159# 0.03684f
C3 VGND CLK 0.01946f
C4 a_1059_315# VPB 0.15474f
C5 a_466_413# VGND 0.0888f
C6 VGND VPB 0.01223f
C7 a_1059_315# Q 0.08125f
C8 VGND Q 0.07661f
C9 a_891_413# a_27_47# 0.03224f
C10 VGND a_1059_315# 0.15512f
C11 VPWR CLK 0.01941f
C12 a_466_413# VPWR 0.17098f
C13 a_466_413# a_634_159# 0.23992f
C14 VPWR VPB 0.16818f
C15 VPB a_634_159# 0.07647f
C16 VPWR Q 0.11093f
C17 a_193_47# D 0.17578f
C18 a_466_413# a_381_47# 0.03733f
C19 CLK a_27_47# 0.21384f
C20 VPWR a_1059_315# 0.23245f
C21 VPB a_381_47# 0.01414f
C22 VGND VPWR 0.06389f
C23 a_466_413# a_27_47# 0.27314f
C24 VGND a_634_159# 0.12488f
C25 VPB a_27_47# 0.24782f
C26 VGND a_381_47# 0.05222f
C27 a_891_413# a_193_47# 0.19685f
C28 a_1059_315# a_27_47# 0.04875f
C29 VGND a_27_47# 0.13669f
C30 VPWR a_634_159# 0.10213f
C31 VPWR a_381_47# 0.06128f
C32 VPWR a_27_47# 0.37986f
C33 a_634_159# a_27_47# 0.14145f
C34 a_466_413# a_193_47# 0.08301f
C35 VPB a_193_47# 0.17613f
C36 VPB D 0.09633f
C37 a_381_47# a_27_47# 0.06222f
C38 a_1059_315# a_193_47# 0.03405f
C39 VGND a_193_47# 0.2001f
C40 VGND D 0.03899f
C41 a_891_413# VPB 0.06977f
C42 a_891_413# a_1059_315# 0.31086f
C43 VPWR a_193_47# 0.11722f
C44 VPWR D 0.02507f
C45 a_634_159# a_193_47# 0.12729f
C46 a_891_413# VGND 0.13154f
C47 VPB CLK 0.07006f
C48 a_381_47# a_193_47# 0.10164f
C49 a_381_47# D 0.11219f
C50 a_466_413# VPB 0.07446f
C51 a_193_47# a_27_47# 0.97453f
C52 a_27_47# D 0.06586f
C53 Q VNB 0.08826f
C54 VGND VNB 0.84362f
C55 VPWR VNB 0.68137f
C56 D VNB 0.14251f
C57 CLK VNB 0.19598f
C58 VPB VNB 1.49072f
C59 a_381_47# VNB 0.01537f
C60 a_891_413# VNB 0.16105f
C61 a_1059_315# VNB 0.24885f
C62 a_466_413# VNB 0.1332f
C63 a_634_159# VNB 0.14231f
C64 a_193_47# VNB 0.28426f
C65 a_27_47# VNB 0.44951f
.ends

.subckt sky130_fd_pr__res_xhigh_po_0p35_PZSUGD R1_4 R1_3 R1_2 R1_1 R1_0 B R2_5 R2_4
+ R2_3 R2_2 R2_1 R2_0 R1_5
X0 R1_4 R2_4 B sky130_fd_pr__res_xhigh_po_0p35 l=30.3
X1 R1_2 R2_2 B sky130_fd_pr__res_xhigh_po_0p35 l=30.3
X2 R1_5 R2_5 B sky130_fd_pr__res_xhigh_po_0p35 l=30.3
X3 R1_0 R2_0 B sky130_fd_pr__res_xhigh_po_0p35 l=30.3
X4 R1_1 R2_1 B sky130_fd_pr__res_xhigh_po_0p35 l=30.3
X5 R1_3 R2_3 B sky130_fd_pr__res_xhigh_po_0p35 l=30.3
C0 R1_1 R1_0 0.29626f
C1 R2_4 R2_5 0.29626f
C2 R2_1 R2_2 0.29626f
C3 R1_2 R1_1 0.29626f
C4 R2_2 R2_3 0.29626f
C5 R1_2 R1_3 0.29626f
C6 R1_3 R1_4 0.29626f
C7 R1_4 R1_5 0.29626f
C8 R2_4 R2_3 0.29626f
C9 R2_1 R2_0 0.29626f
C10 R2_5 B 0.40066f
C11 R1_5 B 0.40066f
C12 R2_4 B 0.17894f
C13 R1_4 B 0.17894f
C14 R2_3 B 0.17883f
C15 R1_3 B 0.17883f
C16 R2_2 B 0.17883f
C17 R1_2 B 0.17883f
C18 R2_1 B 0.17894f
C19 R1_1 B 0.17894f
C20 R2_0 B 0.40066f
C21 R1_0 B 0.40066f
.ends

.subckt vco_adc_half a_4654_26861# mon/A xq3/X CM1/C1 a_520_37976# a_1906_26237# w_440_39556#
+ a_586_39570# xq1/A a_3032_26237# xq6/A a_1800_26100# mon/X xq6/VPB xq4/X xq1/VPB
+ dq6/CLK xq5/VPB xq6/X CM1/C2 dff6/CLK dff5/D xq3/A xq4/A xq0/A xq5/A w_2846_27270#
+ xq5/X RIN/R2_0 dff4/D xq2/A RIN/B xq3/VPB
Xxq4 RIN/B xq5/VPB xq5/VPB RIN/B xq4/A xq4/X xq4/B xq4/a_285_297# xq4/a_35_297# sky130_fd_sc_hd__xor2_1
Xdff2 RIN/B xq1/VPB RIN/B xq1/VPB xq3/A dff2/D dff6/CLK dff2/a_891_413# dff2/a_193_47#
+ dff2/a_381_47# dff2/a_1062_300# dff2/a_475_413# dff2/a_634_183# dff2/a_27_47# sky130_fd_sc_hd__dfxtp_4
Xxq5 RIN/B xq5/VPB xq5/VPB RIN/B xq5/A xq5/X xq5/B xq5/a_285_297# xq5/a_35_297# sky130_fd_sc_hd__xor2_1
Xdff3 RIN/B xq1/VPB RIN/B xq1/VPB xq4/A dff3/D dff6/CLK dff3/a_891_413# dff3/a_193_47#
+ dff3/a_381_47# dff3/a_1062_300# dff3/a_475_413# dff3/a_634_183# dff3/a_27_47# sky130_fd_sc_hd__dfxtp_4
Xxq6 RIN/B xq6/VPB xq6/VPB RIN/B xq6/A xq6/X xq6/B xq6/a_285_297# xq6/a_35_297# sky130_fd_sc_hd__xor2_1
Xdff4 RIN/B xq1/VPB RIN/B xq1/VPB xq5/A dff4/D dff6/CLK dff4/a_891_413# dff4/a_193_47#
+ dff4/a_381_47# dff4/a_1062_300# dff4/a_475_413# dff4/a_634_183# dff4/a_27_47# sky130_fd_sc_hd__dfxtp_4
Xdff5 RIN/B xq1/VPB RIN/B xq1/VPB xq6/A dff5/D dff6/CLK dff5/a_891_413# dff5/a_193_47#
+ dff5/a_381_47# dff5/a_1062_300# dff5/a_475_413# dff5/a_634_183# dff5/a_27_47# sky130_fd_sc_hd__dfxtp_4
Xdff6 RIN/B xq3/VPB RIN/B xq3/VPB xq2/A dff6/D dff6/CLK dff6/a_891_413# dff6/a_193_47#
+ dff6/a_381_47# dff6/a_1062_300# dff6/a_475_413# dff6/a_634_183# dff6/a_27_47# sky130_fd_sc_hd__dfxtp_4
XRIN RIN/R1_1 RIN/R1_1 RIN/B CM1/C1 RIN/R2_0 sky130_fd_pr__res_xhigh_po_0p35_Y3K97R
Xmon xq3/VPB RIN/B mon/X mon/A xq3/VPB RIN/B mon/a_27_47# sky130_fd_sc_hd__buf_4
XCM0 CM1/C1 CM1/C2 RIN/B sky130_fd_pr__cap_mim_m3_1_4SMZ5E
XCM1 CM1/C1 CM1/C2 RIN/B sky130_fd_pr__cap_mim_m3_1_4SMZ5E
Xdq0 xq0/B dq6/CLK xq0/A xq1/VPB RIN/B xq1/VPB RIN/B dq0/a_891_413# dq0/a_466_413#
+ dq0/a_1059_315# dq0/a_193_47# dq0/a_634_159# dq0/a_381_47# dq0/a_27_47# sky130_fd_sc_hd__dfxtp_1
Xdq1 xq1/B dq6/CLK xq1/A xq1/VPB RIN/B xq1/VPB RIN/B dq1/a_891_413# dq1/a_466_413#
+ dq1/a_1059_315# dq1/a_193_47# dq1/a_634_159# dq1/a_381_47# dq1/a_27_47# sky130_fd_sc_hd__dfxtp_1
XRD0 RD0/R1_5 RD0/R1_3 RD0/R1_3 RD0/R1_1 RD0/R1_1 RIN/B CM1/C1 RD0/R2_4 RD0/R2_4 RD0/R2_2
+ RD0/R2_2 xq0/X RD0/R1_5 sky130_fd_pr__res_xhigh_po_0p35_PZSUGD
Xdq2 xq2/B dq6/CLK xq2/A xq3/VPB RIN/B xq3/VPB RIN/B dq2/a_891_413# dq2/a_466_413#
+ dq2/a_1059_315# dq2/a_193_47# dq2/a_634_159# dq2/a_381_47# dq2/a_27_47# sky130_fd_sc_hd__dfxtp_1
XRD1 RD1/R1_5 RD1/R1_3 RD1/R1_3 RD1/R1_1 RD1/R1_1 RIN/B CM1/C1 RD1/R2_4 RD1/R2_4 RD1/R2_2
+ RD1/R2_2 xq1/X RD1/R1_5 sky130_fd_pr__res_xhigh_po_0p35_PZSUGD
Xdq3 xq3/B dq6/CLK xq3/A xq3/VPB RIN/B xq3/VPB RIN/B dq3/a_891_413# dq3/a_466_413#
+ dq3/a_1059_315# dq3/a_193_47# dq3/a_634_159# dq3/a_381_47# dq3/a_27_47# sky130_fd_sc_hd__dfxtp_1
XRD2 RD2/R1_5 RD2/R1_3 RD2/R1_3 RD2/R1_1 RD2/R1_1 RIN/B CM1/C1 RD2/R2_4 RD2/R2_4 RD2/R2_2
+ RD2/R2_2 xq2/X RD2/R1_5 sky130_fd_pr__res_xhigh_po_0p35_PZSUGD
Xdq4 xq4/B dq6/CLK xq4/A xq5/VPB RIN/B xq5/VPB RIN/B dq4/a_891_413# dq4/a_466_413#
+ dq4/a_1059_315# dq4/a_193_47# dq4/a_634_159# dq4/a_381_47# dq4/a_27_47# sky130_fd_sc_hd__dfxtp_1
Xxq0 RIN/B xq1/VPB xq1/VPB RIN/B xq0/A xq0/X xq0/B xq0/a_285_297# xq0/a_35_297# sky130_fd_sc_hd__xor2_1
XRD3 RD3/R1_5 RD3/R1_3 RD3/R1_3 RD3/R1_1 RD3/R1_1 RIN/B CM1/C1 RD3/R2_4 RD3/R2_4 RD3/R2_2
+ RD3/R2_2 xq3/X RD3/R1_5 sky130_fd_pr__res_xhigh_po_0p35_PZSUGD
XRD4 RD4/R1_5 RD4/R1_3 RD4/R1_3 RD4/R1_1 RD4/R1_1 RIN/B CM1/C1 RD4/R2_4 RD4/R2_4 RD4/R2_2
+ RD4/R2_2 xq4/X RD4/R1_5 sky130_fd_pr__res_xhigh_po_0p35_PZSUGD
Xdq5 xq5/B dq6/CLK xq5/A xq5/VPB RIN/B xq5/VPB RIN/B dq5/a_891_413# dq5/a_466_413#
+ dq5/a_1059_315# dq5/a_193_47# dq5/a_634_159# dq5/a_381_47# dq5/a_27_47# sky130_fd_sc_hd__dfxtp_1
Xxq1 RIN/B xq1/VPB xq1/VPB RIN/B xq1/A xq1/X xq1/B xq1/a_285_297# xq1/a_35_297# sky130_fd_sc_hd__xor2_1
XRD5 RD5/R1_5 RD5/R1_3 RD5/R1_3 RD5/R1_1 RD5/R1_1 RIN/B CM1/C1 RD5/R2_4 RD5/R2_4 RD5/R2_2
+ RD5/R2_2 xq5/X RD5/R1_5 sky130_fd_pr__res_xhigh_po_0p35_PZSUGD
Xdff0 RIN/B xq3/VPB RIN/B xq3/VPB xq0/A mon/A dff6/CLK dff0/a_891_413# dff0/a_193_47#
+ dff0/a_381_47# dff0/a_1062_300# dff0/a_475_413# dff0/a_634_183# dff0/a_27_47# sky130_fd_sc_hd__dfxtp_4
Xdq6 xq6/B dq6/CLK xq6/A xq6/VPB RIN/B xq6/VPB RIN/B dq6/a_891_413# dq6/a_466_413#
+ dq6/a_1059_315# dq6/a_193_47# dq6/a_634_159# dq6/a_381_47# dq6/a_27_47# sky130_fd_sc_hd__dfxtp_1
Xxq2 RIN/B xq3/VPB xq3/VPB RIN/B xq2/A xq2/X xq2/B xq2/a_285_297# xq2/a_35_297# sky130_fd_sc_hd__xor2_1
XRD6 RD6/R1_5 RD6/R1_3 RD6/R1_3 RD6/R1_1 RD6/R1_1 RIN/B CM1/C1 RD6/R2_4 RD6/R2_4 RD6/R2_2
+ RD6/R2_2 xq6/X RD6/R1_5 sky130_fd_pr__res_xhigh_po_0p35_PZSUGD
Xdff1 RIN/B xq3/VPB RIN/B xq3/VPB xq1/A dff1/D dff6/CLK dff1/a_891_413# dff1/a_193_47#
+ dff1/a_381_47# dff1/a_1062_300# dff1/a_475_413# dff1/a_634_183# dff1/a_27_47# sky130_fd_sc_hd__dfxtp_4
Xxq3 RIN/B xq3/VPB xq3/VPB RIN/B xq3/A xq3/X xq3/B xq3/a_285_297# xq3/a_35_297# sky130_fd_sc_hd__xor2_1
X0 dff1/D mon/A a_2366_39596# w_440_39556# sky130_fd_pr__pfet_01v8 ad=0.33 pd=2.66 as=0.15 ps=1.3 w=1 l=0.15
X1 CM1/C2 a_3032_27474# w_2846_27270# w_2846_27270# sky130_fd_pr__pfet_01v8 ad=0.74 pd=4.37 as=1.32 ps=8.66 w=4 l=1
X2 dff6/D dff1/D a_2846_39596# w_440_39556# sky130_fd_pr__pfet_01v8 ad=0.33 pd=2.66 as=0.15 ps=1.3 w=1 l=0.15
X3 mon/A dff5/D a_1886_39236# RIN/B sky130_fd_pr__nfet_01v8 ad=0.165 pd=1.66 as=0.075 ps=0.8 w=0.5 l=0.15
X4 CM1/C1 a_4654_26861# CM1/C2 RIN/B sky130_fd_pr__nfet_01v8 ad=0.1386 pd=1.5 as=0.1386 ps=1.5 w=0.42 l=0.15
X5 mon/A dff5/D a_1886_39596# w_440_39556# sky130_fd_pr__pfet_01v8 ad=0.33 pd=2.66 as=0.15 ps=1.3 w=1 l=0.15
X6 a_2306_26380# a_1906_26237# RIN/B RIN/B sky130_fd_pr__nfet_01v8 ad=0.37 pd=2.37 as=0.66 ps=4.66 w=2 l=2
X7 RIN/B dff5/D RIN/B RIN/B sky130_fd_pr__nfet_01v8 ad=0.49 pd=3.5 as=22.80923 ps=225.33 w=1.4 l=2.86
X8 w_2846_27270# a_3032_27474# a_3032_27474# w_2846_27270# sky130_fd_pr__pfet_01v8 ad=1.32 pd=8.66 as=0.74 ps=4.37 w=4 l=1
X9 a_3326_39236# a_1066_39096# RIN/B RIN/B sky130_fd_pr__nfet_01v8 ad=0.075 pd=0.8 as=0.165 ps=1.66 w=0.5 l=1
X10 a_3806_39236# a_1066_39096# RIN/B RIN/B sky130_fd_pr__nfet_01v8 ad=0.075 pd=0.8 as=0.165 ps=1.66 w=0.5 l=1
X11 a_586_39570# CM1/C2 a_520_37976# RIN/B sky130_fd_pr__nfet_01v8 ad=1.32 pd=8.66 as=1.32 ps=8.66 w=4 l=1
X12 a_3326_39596# a_586_39570# w_440_39556# w_440_39556# sky130_fd_pr__pfet_01v8 ad=0.15 pd=1.3 as=0.33 ps=2.66 w=1 l=1
X13 a_2366_39236# a_1066_39096# RIN/B RIN/B sky130_fd_pr__nfet_01v8 ad=0.075 pd=0.8 as=0.165 ps=1.66 w=0.5 l=1
X14 a_2366_39596# a_586_39570# w_440_39556# w_440_39556# sky130_fd_pr__pfet_01v8 ad=0.15 pd=1.3 as=0.33 ps=2.66 w=1 l=1
X15 a_3806_39596# a_586_39570# w_440_39556# w_440_39556# sky130_fd_pr__pfet_01v8 ad=0.15 pd=1.3 as=0.33 ps=2.66 w=1 l=1
X16 a_2846_39236# a_1066_39096# RIN/B RIN/B sky130_fd_pr__nfet_01v8 ad=0.075 pd=0.8 as=0.165 ps=1.66 w=0.5 l=1
X17 a_3032_27474# a_3032_26237# a_2306_26380# RIN/B sky130_fd_pr__nfet_01v8 ad=0.74 pd=4.37 as=1.32 ps=8.66 w=4 l=1
X18 a_2306_26380# CM1/C1 CM1/C2 RIN/B sky130_fd_pr__nfet_01v8 ad=1.32 pd=8.66 as=0.74 ps=4.37 w=4 l=1
X19 a_2846_39596# a_586_39570# w_440_39556# w_440_39556# sky130_fd_pr__pfet_01v8 ad=0.15 pd=1.3 as=0.33 ps=2.66 w=1 l=1
X20 a_1886_39236# a_1066_39096# RIN/B RIN/B sky130_fd_pr__nfet_01v8 ad=0.075 pd=0.8 as=0.165 ps=1.66 w=0.5 l=1
X21 a_1886_39596# a_586_39570# w_440_39556# w_440_39556# sky130_fd_pr__pfet_01v8 ad=0.15 pd=1.3 as=0.33 ps=2.66 w=1 l=1
X22 a_1066_39096# a_1066_39096# RIN/B RIN/B sky130_fd_pr__nfet_01v8 ad=0.165 pd=1.66 as=0.165 ps=1.66 w=0.5 l=1
X23 CM1/C2 CM1/C1 a_2306_26380# RIN/B sky130_fd_pr__nfet_01v8 ad=0.74 pd=4.37 as=1.32 ps=8.66 w=4 l=1
X24 a_1066_39096# a_586_39570# w_440_39556# w_440_39556# sky130_fd_pr__pfet_01v8 ad=0.33 pd=2.66 as=0.33 ps=2.66 w=1 l=1
X25 RIN/B dff4/D RIN/B RIN/B sky130_fd_pr__nfet_01v8 ad=0.49 pd=3.5 as=0 ps=0 w=1.4 l=2.86
X26 RIN/B a_1906_26237# a_2306_26380# RIN/B sky130_fd_pr__nfet_01v8 ad=0.66 pd=4.66 as=0.37 ps=2.37 w=2 l=2
X27 RIN/B dff2/D RIN/B RIN/B sky130_fd_pr__nfet_01v8 ad=0.49 pd=3.5 as=0 ps=0 w=1.4 l=2.86
X28 dff4/D dff3/D a_4286_39236# RIN/B sky130_fd_pr__nfet_01v8 ad=0.165 pd=1.66 as=0.075 ps=0.8 w=0.5 l=0.15
X29 RIN/B dff3/D RIN/B RIN/B sky130_fd_pr__nfet_01v8 ad=0.49 pd=3.5 as=0 ps=0 w=1.4 l=2.86
X30 dff5/D dff4/D a_4766_39236# RIN/B sky130_fd_pr__nfet_01v8 ad=0.165 pd=1.66 as=0.075 ps=0.8 w=0.5 l=0.15
X31 RIN/B dff1/D RIN/B RIN/B sky130_fd_pr__nfet_01v8 ad=0.49 pd=3.5 as=0 ps=0 w=1.4 l=2.86
X32 a_586_39570# a_586_39570# w_440_39556# w_440_39556# sky130_fd_pr__pfet_01v8 ad=0.33 pd=2.66 as=0.33 ps=2.66 w=1 l=1
X33 dff4/D dff3/D a_4286_39596# w_440_39556# sky130_fd_pr__pfet_01v8 ad=0.33 pd=2.66 as=0.15 ps=1.3 w=1 l=0.15
X34 dff2/D dff6/D a_3326_39236# RIN/B sky130_fd_pr__nfet_01v8 ad=0.165 pd=1.66 as=0.075 ps=0.8 w=0.5 l=0.15
X35 RIN/B dff6/D RIN/B RIN/B sky130_fd_pr__nfet_01v8 ad=0.49 pd=3.5 as=0 ps=0 w=1.4 l=2.86
X36 a_2306_26380# a_3032_26237# a_3032_27474# RIN/B sky130_fd_pr__nfet_01v8 ad=1.32 pd=8.66 as=0.74 ps=4.37 w=4 l=1
X37 dff2/D dff6/D a_3326_39596# w_440_39556# sky130_fd_pr__pfet_01v8 ad=0.33 pd=2.66 as=0.15 ps=1.3 w=1 l=0.15
X38 dff5/D dff4/D a_4766_39596# w_440_39556# sky130_fd_pr__pfet_01v8 ad=0.33 pd=2.66 as=0.15 ps=1.3 w=1 l=0.15
X39 dff3/D dff2/D a_3806_39236# RIN/B sky130_fd_pr__nfet_01v8 ad=0.165 pd=1.66 as=0.075 ps=0.8 w=0.5 l=0.15
X40 dff3/D dff2/D a_3806_39596# w_440_39556# sky130_fd_pr__pfet_01v8 ad=0.33 pd=2.66 as=0.15 ps=1.3 w=1 l=0.15
X41 a_4286_39236# a_1066_39096# RIN/B RIN/B sky130_fd_pr__nfet_01v8 ad=0.075 pd=0.8 as=0.165 ps=1.66 w=0.5 l=1
X42 a_4286_39596# a_586_39570# w_440_39556# w_440_39556# sky130_fd_pr__pfet_01v8 ad=0.15 pd=1.3 as=0.33 ps=2.66 w=1 l=1
X43 a_4766_39236# a_1066_39096# RIN/B RIN/B sky130_fd_pr__nfet_01v8 ad=0.075 pd=0.8 as=0.165 ps=1.66 w=0.5 l=1
X44 a_4766_39596# a_586_39570# w_440_39556# w_440_39556# sky130_fd_pr__pfet_01v8 ad=0.15 pd=1.3 as=0.33 ps=2.66 w=1 l=1
X45 w_2846_27270# a_3032_27474# CM1/C2 w_2846_27270# sky130_fd_pr__pfet_01v8 ad=1.32 pd=8.66 as=0.74 ps=4.37 w=4 l=1
X46 a_3032_27474# a_3032_27474# w_2846_27270# w_2846_27270# sky130_fd_pr__pfet_01v8 ad=0.74 pd=4.37 as=1.32 ps=8.66 w=4 l=1
X47 dff1/D mon/A a_2366_39236# RIN/B sky130_fd_pr__nfet_01v8 ad=0.165 pd=1.66 as=0.075 ps=0.8 w=0.5 l=0.15
X48 dff6/D dff1/D a_2846_39236# RIN/B sky130_fd_pr__nfet_01v8 ad=0.165 pd=1.66 as=0.075 ps=0.8 w=0.5 l=0.15
X49 RIN/B mon/A RIN/B RIN/B sky130_fd_pr__nfet_01v8 ad=0.49 pd=3.5 as=0 ps=0 w=1.4 l=2.86
C0 xq3/VPB xq1/X 0.02822f
C1 dq6/a_27_47# dq5/a_27_47# 0.0407f
C2 xq4/a_35_297# xq4/B 0.17659f
C3 xq2/A dff3/a_27_47# 0.01887f
C4 xq3/A dq2/a_27_47# 0.01412f
C5 dq6/CLK dff6/CLK 0.16129f
C6 dff5/D dff3/a_1062_300# 0.01128f
C7 xq4/A xq4/B 0.09776f
C8 xq3/A dq3/a_634_159# 0.01954f
C9 w_2846_27270# CM1/C1 0.15229f
C10 dq6/a_27_47# xq6/A 0.0553f
C11 xq0/X xq5/VPB 0.06639f
C12 dff6/CLK dff0/a_891_413# 0.01706f
C13 dff4/D dff5/D 1.35777f
C14 dff2/a_1062_300# xq3/A 0.03402f
C15 dq4/a_1059_315# dq5/a_1059_315# 0.02605f
C16 xq2/a_35_297# xq3/a_35_297# 0.01441f
C17 xq0/A mon/X 0.76094f
C18 xq1/B xq1/a_35_297# 0.17659f
C19 xq5/X xq4/X 6.51062f
C20 dff3/a_634_183# dff5/D 0.02103f
C21 dff6/a_27_47# dff2/a_1062_300# 0.01191f
C22 dff2/a_27_47# dff6/CLK 0.10428f
C23 dff6/D dff0/a_1062_300# 0.04023f
C24 xq2/A dq2/a_27_47# 0.05619f
C25 dff0/a_475_413# dff2/D 0.01854f
C26 dq6/CLK mon/X 0.06652f
C27 xq0/A dff2/a_193_47# 0.01407f
C28 CM1/C1 CM1/C2 2.42632f
C29 RD0/R2_4 CM1/C1 0.01655f
C30 xq5/B xq5/a_35_297# 0.17659f
C31 a_4654_26861# CM1/C1 0.42886f
C32 dff5/D dff3/D 0.34741f
C33 xq0/X xq4/A 0.0179f
C34 xq3/B xq3/A 0.09776f
C35 xq3/X xq4/X 6.91734f
C36 xq3/X xq5/X 0.10657f
C37 dff2/a_475_413# mon/a_27_47# 0.01337f
C38 xq3/VPB dff4/D 0.13509f
C39 dff3/a_27_47# dff5/a_27_47# 0.01359f
C40 xq2/X RIN/R2_0 0.0402f
C41 xq3/a_35_297# xq3/A 0.02709f
C42 dff6/CLK mon/A 0.26022f
C43 xq0/a_285_297# xq0/X 0.02272f
C44 xq4/X xq6/X 0.10999f
C45 dff6/a_1062_300# dff3/a_193_47# 0.01098f
C46 a_1066_39096# w_440_39556# 0.10549f
C47 xq5/X xq6/X 5.66136f
C48 dff2/a_27_47# dff2/a_193_47# -0.01246f
C49 xq3/VPB dff3/D 0.13328f
C50 dq3/a_1059_315# dq2/a_1059_315# 0.02605f
C51 dff2/a_381_47# dff6/CLK 0.01307f
C52 dff2/D dff5/D 0.12333f
C53 dq5/a_1059_315# xq5/B 0.02886f
C54 xq1/B xq0/B 0.02433f
C55 dff4/D dff4/a_193_47# 0.05082f
C56 xq3/X xq6/X 0.10745f
C57 xq3/VPB dq3/a_27_47# 0.0501f
C58 dff6/D dff2/a_1062_300# 0.01399f
C59 mon/A mon/X 0.06382f
C60 w_2846_27270# a_3032_26237# 0.13591f
C61 dff4/a_27_47# dff4/a_193_47# -0.01246f
C62 dq0/a_1059_315# xq0/B 0.02886f
C63 a_4766_39596# dff5/D 0.01037f
C64 xq0/A dff5/a_193_47# 0.01611f
C65 xq1/A dff3/a_193_47# 0.01526f
C66 dff1/D a_586_39570# 0.13562f
C67 dff2/a_193_47# mon/A 0.01254f
C68 xq1/A dq1/a_891_413# 0.02303f
C69 a_3032_26237# CM1/C2 0.3574f
C70 xq3/VPB dff2/D 0.12265f
C71 xq2/X xq6/VPB 0.02891f
C72 a_3032_26237# a_4654_26861# 0.34111f
C73 RD2/R2_2 CM1/C1 0.01627f
C74 dff6/CLK dff0/a_1062_300# 0.06646f
C75 xq2/A dff3/a_193_47# 0.01706f
C76 dff3/a_27_47# dff6/CLK 0.03433f
C77 mon/A a_1066_39096# 0.1269f
C78 CM1/C1 xq1/X 0.14884f
C79 dff4/a_1062_300# xq0/A 0.02077f
C80 dq3/a_466_413# dq2/a_466_413# 0.01384f
C81 xq0/a_35_297# xq0/A 0.02709f
C82 xq3/A dq2/a_193_47# 0.01037f
C83 xq6/B xq6/A 0.09776f
C84 xq1/VPB dq0/a_27_47# 0.0501f
C85 dq5/a_27_47# xq5/VPB 0.0501f
C86 dq3/a_1059_315# dq4/a_1059_315# 0.02513f
C87 dff4/D dff4/a_27_47# 0.07808f
C88 xq1/VPB xq3/A 0.2438f
C89 xq1/VPB xq1/A 0.25569f
C90 dq1/a_891_413# dq0/a_891_413# 0.01464f
C91 dff4/D dff3/D 1.25808f
C92 xq4/a_35_297# xq5/a_35_297# 0.01441f
C93 xq5/VPB xq6/A 0.0422f
C94 dff6/a_1062_300# xq1/A 0.01094f
C95 dff5/a_1062_300# xq1/VPB 0.01793f
C96 xq2/A dq2/a_193_47# 0.07828f
C97 xq3/B xq2/B 0.02433f
C98 xq4/A dff5/D 0.02024f
C99 xq5/A xq1/VPB 0.19906f
C100 xq4/A dq5/a_27_47# 0.01017f
C101 xq2/a_35_297# xq2/A 0.02709f
C102 xq5/A dq4/a_27_47# 0.01218f
C103 dff1/a_891_413# xq1/A 0.0154f
C104 xq3/VPB xq5/VPB 0.02013f
C105 xq2/A xq1/VPB 0.08772f
C106 dff6/CLK dff2/a_1062_300# 0.0648f
C107 xq0/A dff5/D 0.0108f
C108 a_3032_27474# a_2306_26380# 0.53059f
C109 xq4/X RIN/R2_0 0.04852f
C110 xq1/A dq0/a_27_47# 0.01756f
C111 dff0/a_193_47# dff6/CLK 0.04812f
C112 a_1906_26237# CM1/C2 1.17998f
C113 xq5/X RIN/R2_0 0.0671f
C114 RD5/R2_2 CM1/C1 0.01627f
C115 dff6/a_1062_300# xq2/A 0.05329f
C116 w_440_39556# dff5/D 0.57835f
C117 RD2/R1_5 RD3/R1_1 0.05012f
C118 xq1/A xq3/A 0.06193f
C119 a_1906_26237# a_4654_26861# 2.06397f
C120 xq0/X xq2/X 0.12437f
C121 xq4/A xq6/A 0.39525f
C122 dq6/CLK dq5/a_27_47# 0.02678f
C123 dq6/a_1059_315# xq6/A 0.02906f
C124 mon/A dff0/a_475_413# 0.02815f
C125 dff4/D dff2/D 0.44039f
C126 xq0/A xq6/A 0.10233f
C127 xq1/X xq5/VPB 0.0266f
C128 xq3/X RIN/R2_0 0.03758f
C129 xq3/VPB xq4/A 0.03347f
C130 xq5/A xq3/A 0.75366f
C131 dq2/a_634_159# dq1/a_634_159# 0.01366f
C132 dff6/D dff1/D 0.63189f
C133 dff1/a_1062_300# xq1/A 0.05005f
C134 dff6/D a_586_39570# 0.13733f
C135 xq2/A xq3/A 3.91092f
C136 xq0/A xq3/VPB 0.22887f
C137 xq5/A xq1/A 0.06183f
C138 dq6/CLK xq6/A 1.41229f
C139 CM1/C1 RD4/R2_2 0.01627f
C140 xq2/A xq1/A 4.33356f
C141 dq6/a_1059_315# dq5/a_1059_315# 0.02513f
C142 xq2/A dff6/a_27_47# 0.01367f
C143 dff2/D dff3/D 0.90522f
C144 RIN/R2_0 xq6/X 0.13026f
C145 dq6/CLK xq3/VPB 0.27821f
C146 xq3/B xq4/B 0.02479f
C147 dff6/CLK dff0/a_27_47# 0.08021f
C148 a_3032_27474# RIN/R2_0 0.15057f
C149 dff6/a_27_47# dff6/a_193_47# -0.01246f
C150 dff6/CLK dff2/a_475_413# 0.02027f
C151 dff3/a_193_47# dff6/a_891_413# 0.01276f
C152 xq1/VPB dff5/a_27_47# 0.05977f
C153 xq5/A xq2/A 0.39874f
C154 dff6/CLK dff4/a_475_413# 0.02241f
C155 xq1/A dff5/a_475_413# 0.01246f
C156 xq4/X xq6/VPB 0.02901f
C157 xq0/A dff4/a_193_47# 0.02754f
C158 xq5/X xq6/VPB 0.03062f
C159 xq4/A dq4/a_1059_315# 0.02906f
C160 mon/A dff5/D 0.18554f
C161 dff6/CLK dff3/a_193_47# 0.02259f
C162 dq4/a_193_47# dq3/a_193_47# 0.0272f
C163 xq2/A dff6/a_193_47# 0.01075f
C164 xq6/B xq5/B 0.02479f
C165 mon/X dff0/a_27_47# 0.01404f
C166 dff6/D dff6/a_27_47# 0.07813f
C167 dq6/a_891_413# dq5/a_891_413# 0.01593f
C168 RD6/R2_4 CM1/C1 0.01655f
C169 RD1/R1_1 RD0/R1_5 0.05012f
C170 xq3/X xq6/VPB 0.02886f
C171 xq2/a_35_297# xq2/B 0.17659f
C172 dq4/a_891_413# dq5/a_891_413# 0.01464f
C173 xq1/A dff5/a_27_47# 0.02039f
C174 xq0/A xq0/B 0.09776f
C175 xq4/A dff3/a_1062_300# 0.03272f
C176 xq0/A dq0/a_1059_315# 0.02906f
C177 xq5/B xq5/VPB 0.03413f
C178 mon/A xq3/VPB 0.1416f
C179 dq6/a_27_47# dq6/CLK 0.02528f
C180 xq6/VPB xq6/X 0.38917f
C181 xq5/A dff5/a_27_47# 0.01165f
C182 dff6/D dff6/a_193_47# 0.0509f
C183 xq2/A dff5/a_27_47# 0.01273f
C184 xq0/A dff4/D 0.12334f
C185 dff6/CLK dff1/D 0.03781f
C186 dq2/a_891_413# dq1/a_891_413# 0.01593f
C187 xq3/X xq3/a_285_297# 0.01864f
C188 dff3/a_891_413# xq1/A 0.01267f
C189 xq1/VPB dff6/CLK 0.50994f
C190 xq0/A dff4/a_27_47# 0.02734f
C191 dq4/a_193_47# xq4/A 0.07787f
C192 xq2/A dq2/a_381_47# 0.01396f
C193 w_440_39556# dff4/D 0.33989f
C194 RD1/R2_4 CM1/C1 0.01655f
C195 dff1/a_27_47# dff1/D 0.04369f
C196 dff3/a_27_47# dff5/D 0.05556f
C197 a_3032_26237# CM1/C1 0.62564f
C198 xq0/X xq4/X 0.12084f
C199 dff6/CLK mon/a_27_47# 0.04332f
C200 dff4/D dff0/a_891_413# 0.02028f
C201 xq0/X xq5/X 0.12042f
C202 w_440_39556# dff3/D 0.33455f
C203 dff6/a_1062_300# dff1/a_27_47# 0.01095f
C204 dff1/D dff1/a_193_47# 0.07821f
C205 dff2/a_27_47# dff4/D 0.05553f
C206 RD3/R2_2 CM1/C1 0.01627f
C207 xq2/A xq2/B 0.09776f
C208 xq1/VPB mon/X 0.03735f
C209 dff6/CLK xq3/A 0.62702f
C210 dff5/a_381_47# dff5/D 0.01244f
C211 dq6/a_891_413# xq6/A 0.02207f
C212 xq3/X xq0/X 0.1218f
C213 xq3/VPB dff0/a_1062_300# 0.01526f
C214 dff2/a_27_47# dff4/a_27_47# 0.01359f
C215 dq6/CLK dq3/a_27_47# 0.02678f
C216 dff6/a_27_47# dff6/CLK 0.048f
C217 mon/X mon/a_27_47# 0.01809f
C218 xq2/A dff6/a_891_413# 0.01406f
C219 xq3/VPB xq2/X 0.29288f
C220 xq0/A dff2/D 0.02272f
C221 xq0/X xq6/X 0.12369f
C222 xq5/A dff6/CLK 0.45337f
C223 a_1066_39096# dff1/D 0.11111f
C224 xq1/VPB xq0/X 0.28048f
C225 mon/A dff4/D 0.38739f
C226 xq2/A dff6/CLK 0.15721f
C227 a_1066_39096# a_586_39570# 0.19517f
C228 w_440_39556# dff2/D 0.34216f
C229 xq3/A dq3/a_466_413# 0.01596f
C230 xq4/a_285_297# xq4/X 0.01862f
C231 xq3/VPB dq2/a_27_47# 0.0501f
C232 xq2/X xq1/X 8.177f
C233 dff6/CLK dff6/a_193_47# 0.02544f
C234 xq5/A dq5/a_381_47# 0.01382f
C235 xq2/A dff1/a_27_47# 0.01046f
C236 a_1906_26237# CM1/C1 0.45051f
C237 xq5/A dff4/a_891_413# 0.01224f
C238 xq6/B dq6/a_1059_315# 0.02886f
C239 dff6/CLK dff4/a_634_183# 0.01586f
C240 dff2/a_27_47# dff2/D 0.04436f
C241 dq4/a_193_47# dq5/a_193_47# 0.0272f
C242 xq0/X xq3/A 0.0179f
C243 dq4/a_466_413# dq3/a_466_413# 0.01385f
C244 dq6/a_634_159# xq6/A 0.01899f
C245 xq0/X xq1/A 0.0179f
C246 xq2/A dq2/a_891_413# 0.02236f
C247 dff6/D dff6/CLK 0.14436f
C248 xq4/A xq5/VPB 0.15684f
C249 xq1/VPB dff5/a_193_47# 0.01044f
C250 dq4/a_891_413# dq3/a_891_413# 0.01593f
C251 dq1/a_634_159# dq0/a_634_159# 0.01245f
C252 xq5/A xq0/X 0.0179f
C253 xq3/B xq3/VPB 0.03413f
C254 dff6/CLK dff5/a_27_47# 0.03089f
C255 dff4/D dff0/a_1062_300# 0.02264f
C256 mon/A dff2/D 0.94195f
C257 xq2/A xq0/X 0.0179f
C258 xq4/A xq4/a_35_297# 0.02709f
C259 xq1/A dq1/a_1059_315# 0.03011f
C260 dq6/CLK xq5/VPB 0.27772f
C261 dff3/a_193_47# dff5/D 0.0554f
C262 dff6/D mon/X 0.0106f
C263 w_2846_27270# a_3032_27474# 2.46694f
C264 xq2/a_285_297# xq2/X 0.01866f
C265 mon/A dff0/a_381_47# 0.0127f
C266 dff4/a_1062_300# xq1/VPB 0.02079f
C267 dff2/a_381_47# dff2/D 0.01227f
C268 xq3/VPB dff0/a_27_47# 0.0594f
C269 xq0/A xq4/A 0.07757f
C270 xq6/a_35_297# xq5/a_35_297# 0.01594f
C271 a_520_37976# a_586_39570# 0.08048f
C272 dff3/a_27_47# dff3/D 0.04436f
C273 xq1/A dff5/a_193_47# 0.02061f
C274 dq6/a_466_413# xq6/A 0.01481f
C275 CM1/C2 a_586_39570# 0.08084f
C276 dq6/CLK xq4/A 0.59373f
C277 a_3032_27474# CM1/C2 0.58072f
C278 a_3032_26237# a_1906_26237# 2.33865f
C279 xq5/a_285_297# xq5/X 0.01861f
C280 dff2/a_634_183# dff6/CLK 0.01694f
C281 a_3032_27474# a_4654_26861# 0.06918f
C282 dq6/CLK xq0/A 0.53294f
C283 xq6/A xq6/a_35_297# 0.02709f
C284 dff6/D a_1066_39096# 0.1109f
C285 xq0/X RIN/R2_0 0.04015f
C286 RD2/R1_1 RD1/R1_5 0.05012f
C287 xq0/A dff0/a_891_413# 0.01442f
C288 dff4/a_1062_300# xq3/A 0.0128f
C289 dff1/D dff5/D 0.12315f
C290 xq2/X CM1/C1 0.14639f
C291 dff5/D a_586_39570# 0.23205f
C292 xq5/A dq5/a_891_413# 0.02207f
C293 dff0/a_193_47# dff4/D 0.04895f
C294 xq1/VPB dff5/D 0.1691f
C295 CM1/C1 RD5/R2_4 0.01655f
C296 dff2/a_27_47# xq0/A 0.01492f
C297 dq4/a_27_47# dq5/a_27_47# 0.03757f
C298 dq3/a_27_47# dq2/a_27_47# 0.03757f
C299 dq2/a_634_159# dq3/a_634_159# 0.01245f
C300 dff6/a_1062_300# dff5/D 0.03989f
C301 dff4/a_1062_300# xq5/A 0.03803f
C302 xq3/X xq3/VPB 0.27711f
C303 w_2846_27270# a_2306_26380# 0.12148f
C304 xq4/X xq1/X 0.10427f
C305 xq5/X xq1/X 0.10335f
C306 dff6/CLK dff1/a_27_47# 0.03314f
C307 dff1/a_891_413# dff5/D 0.02556f
C308 xq1/VPB xq6/A 0.17062f
C309 xq3/VPB dff1/D 0.01829f
C310 xq2/a_35_297# xq1/a_35_297# 0.01594f
C311 dff4/a_891_413# dff6/CLK 0.02031f
C312 xq0/A mon/A 0.06409f
C313 dff0/a_634_183# dff4/D 0.01722f
C314 xq1/VPB xq3/VPB 0.04141f
C315 dq1/a_193_47# dq0/a_193_47# 0.0272f
C316 a_2306_26380# CM1/C2 0.73707f
C317 dff6/CLK mon/X 1.06773f
C318 xq3/X xq1/X 0.10688f
C319 dq4/a_634_159# dq5/a_634_159# 0.01245f
C320 dff4/D dff0/a_27_47# 0.04763f
C321 dff5/a_193_47# dff5/a_27_47# -0.01246f
C322 a_2306_26380# a_4654_26861# 0.10478f
C323 xq1/A dff5/D 0.15723f
C324 mon/A w_440_39556# 0.46263f
C325 dff6/a_1062_300# xq3/VPB 0.02168f
C326 dff2/a_475_413# dff4/D 0.02907f
C327 xq0/A dq0/a_634_159# 0.01899f
C328 xq0/X xq6/VPB 0.05752f
C329 xq3/VPB mon/a_27_47# 0.09039f
C330 dff6/CLK dff2/a_193_47# 0.08286f
C331 dff1/a_1062_300# dff5/D 0.0353f
C332 dq4/a_634_159# xq4/A 0.01911f
C333 dff1/a_27_47# dff1/a_193_47# -0.01246f
C334 xq5/A dff5/D 0.01268f
C335 xq3/A xq6/A 0.07104f
C336 xq1/X xq6/X 0.10642f
C337 xq5/A dq5/a_27_47# 0.05671f
C338 dff0/a_193_47# dff2/D 0.06079f
C339 w_2846_27270# RIN/R2_0 0.13991f
C340 xq5/A xq5/a_35_297# 0.02709f
C341 xq1/VPB xq1/X 0.23042f
C342 xq2/A dff5/D 0.1978f
C343 xq3/B dq3/a_1059_315# 0.02886f
C344 xq1/A xq6/A 0.07106f
C345 xq0/A dq0/a_193_47# 0.0775f
C346 xq1/VPB dff4/a_193_47# 0.01044f
C347 xq3/VPB xq3/A 0.21054f
C348 xq2/X xq5/VPB 0.02645f
C349 xq2/A dq2/a_1059_315# 0.02922f
C350 xq1/A xq1/a_35_297# 0.02709f
C351 dff5/a_1062_300# xq6/A 0.03745f
C352 xq3/VPB xq1/A 0.22812f
C353 RD6/R1_1 RD5/R1_5 0.05012f
C354 dff6/a_27_47# xq3/VPB 0.06242f
C355 xq5/A xq6/A 4.16104f
C356 CM1/C2 RIN/R2_0 1.24864f
C357 dff3/a_193_47# dff3/D 0.08276f
C358 dq6/a_193_47# xq6/A 0.07768f
C359 xq2/A xq6/A 0.07042f
C360 xq1/VPB xq1/B 0.03413f
C361 xq5/A xq3/VPB 0.03017f
C362 dq6/a_466_413# dq5/a_466_413# 0.01385f
C363 xq0/A dff0/a_1062_300# 0.03333f
C364 dff6/CLK dff6/a_475_413# 0.0188f
C365 xq1/VPB xq0/B 0.03413f
C366 xq2/A xq3/VPB 0.31877f
C367 dff6/D dff5/D 0.12336f
C368 dff2/D dff0/a_27_47# 0.05572f
C369 xq5/A dq5/a_1059_315# 0.02906f
C370 xq3/A dff4/a_193_47# 0.0129f
C371 xq0/A dq1/a_27_47# 0.01017f
C372 xq1/VPB dff3/a_1062_300# 0.02558f
C373 dq4/a_891_413# xq4/A 0.02207f
C374 dff1/D dff4/D 0.07892f
C375 dff4/D a_586_39570# 0.11449f
C376 dq6/CLK dq1/a_27_47# 0.02678f
C377 dff5/D dff5/a_27_47# 0.07808f
C378 xq1/VPB dff4/D 0.16206f
C379 xq3/A dq3/a_891_413# 0.02221f
C380 xq4/X CM1/C1 0.14475f
C381 xq5/X CM1/C1 0.14433f
C382 xq1/VPB dff4/a_27_47# 0.05835f
C383 xq1/B xq1/A 0.09776f
C384 dff1/D dff3/D 0.24449f
C385 dff4/D mon/a_27_47# 0.0271f
C386 dff6/D xq3/VPB 0.16383f
C387 dff3/a_634_183# dff6/a_1062_300# 0.01389f
C388 dff3/D a_586_39570# 0.13157f
C389 RD1/R2_2 CM1/C1 0.01627f
C390 xq1/VPB dff3/D 0.02292f
C391 dff6/CLK dff0/a_475_413# 0.01144f
C392 dff4/a_381_47# dff4/D 0.01244f
C393 dq6/CLK dq2/a_27_47# 0.02678f
C394 xq4/A dff5/a_891_413# 0.01526f
C395 xq3/X CM1/C1 0.14541f
C396 dff4/a_1062_300# dff6/CLK 0.07337f
C397 dq6/a_634_159# dq5/a_634_159# 0.01366f
C398 xq1/A dff3/a_1062_300# 0.01793f
C399 CM1/C1 RD3/R2_4 0.01655f
C400 dff6/a_1062_300# dff3/D 0.03463f
C401 xq0/A dff2/a_1062_300# 0.0113f
C402 dff4/D xq3/A 0.02072f
C403 dq4/a_27_47# dq3/a_27_47# 0.0407f
C404 xq3/A dff4/a_27_47# 0.01274f
C405 dff1/a_634_183# dff5/D 0.02122f
C406 CM1/C1 xq6/X 0.14421f
C407 dq2/a_1059_315# xq2/B 0.02886f
C408 a_3032_27474# CM1/C1 0.03468f
C409 xq4/a_35_297# xq3/a_35_297# 0.01594f
C410 dff1/D dff2/D 0.08243f
C411 xq1/X RIN/R2_0 0.03327f
C412 xq6/B xq6/a_35_297# 0.17659f
C413 dff2/D a_586_39570# 0.13513f
C414 xq1/VPB dff2/D 0.0216f
C415 xq2/A dff4/D 0.02675f
C416 dff6/a_27_47# dff3/D 0.01268f
C417 xq0/A dq0/a_381_47# 0.01348f
C418 dff1/a_475_413# dff5/D 0.01162f
C419 xq3/A dq3/a_27_47# 0.05845f
C420 dff6/CLK dff5/D 0.03585f
C421 xq3/VPB xq2/B 0.03413f
C422 xq5/A xq5/B 0.09776f
C423 dq1/a_466_413# dq2/a_466_413# 0.01385f
C424 xq6/A xq6/VPB 0.14381f
C425 xq4/X xq5/VPB 0.34018f
C426 xq0/A dff0/a_27_47# 0.01512f
C427 xq1/A dq1/a_634_159# 0.01985f
C428 xq5/X xq5/VPB 0.32365f
C429 xq3/A dff2/a_891_413# 0.01093f
C430 dq3/a_1059_315# xq3/A 0.02906f
C431 xq2/A dff3/D 0.09281f
C432 dq2/a_193_47# dq3/a_193_47# 0.0272f
C433 dff1/a_27_47# dff5/D 0.05275f
C434 xq5/A dq5/a_466_413# 0.0151f
C435 dff6/a_27_47# dff2/a_891_413# 0.01003f
C436 xq0/A dff4/a_475_413# 0.01094f
C437 xq2/A dq2/a_634_159# 0.01943f
C438 dff6/a_193_47# dff3/D 0.01617f
C439 xq0/A dq0/a_466_413# 0.01481f
C440 dq4/a_466_413# dq5/a_466_413# 0.01384f
C441 xq2/A dq3/a_27_47# 0.01017f
C442 xq3/X xq5/VPB 0.02778f
C443 dff6/D dff4/D 0.15195f
C444 dff0/a_193_47# mon/A 0.11789f
C445 dff5/D dff1/a_193_47# 0.0546f
C446 dff6/CLK xq3/VPB 0.4301f
C447 a_2306_26380# CM1/C1 0.69454f
C448 xq1/X xq6/VPB 0.02903f
C449 dq4/a_634_159# dq3/a_634_159# 0.01366f
C450 dq2/a_193_47# dq1/a_193_47# 0.0272f
C451 dff1/a_27_47# xq3/VPB 0.06475f
C452 dff6/D dff3/D 0.04175f
C453 a_3032_27474# a_3032_26237# 0.36889f
C454 dq4/a_27_47# xq5/VPB 0.0501f
C455 xq1/B xq2/B 0.02479f
C456 RD4/R2_4 CM1/C1 0.01655f
C457 xq3/A dq3/a_193_47# 0.07981f
C458 dff3/a_475_413# dff5/D 0.02909f
C459 RD4/R1_5 RD5/R1_1 0.05012f
C460 xq3/VPB mon/X 0.18812f
C461 a_1066_39096# dff5/D 0.3245f
C462 dff6/CLK dff4/a_193_47# 0.06437f
C463 xq1/X xq1/a_285_297# 0.01871f
C464 dff0/a_634_183# mon/A 0.02046f
C465 dq6/a_27_47# xq6/VPB 0.04881f
C466 mon/A dff0/a_27_47# 0.08754f
C467 dq1/a_27_47# dq2/a_27_47# 0.0407f
C468 xq1/VPB xq4/A 0.20486f
C469 xq0/X xq6/A 0.0179f
C470 xq4/A dq4/a_27_47# 0.05564f
C471 xq0/A xq1/VPB 0.25806f
C472 dff2/a_634_183# dff4/D 0.02114f
C473 CM1/C1 RIN/R2_0 0.20858f
C474 w_440_39556# dff1/D 0.33628f
C475 xq1/A dq1/a_381_47# 0.01446f
C476 dff6/D dff2/D 1.0936f
C477 xq0/X xq3/VPB 0.06652f
C478 dq2/a_1059_315# dq1/a_1059_315# 0.02513f
C479 w_440_39556# a_586_39570# 4.10394f
C480 dq3/a_381_47# xq3/A 0.01402f
C481 xq1/A dq1/a_193_47# 0.08223f
C482 dq6/CLK xq1/VPB 0.29765f
C483 xq4/B dq4/a_1059_315# 0.02886f
C484 dff3/a_381_47# dff3/D 0.01227f
C485 w_2846_27270# CM1/C2 0.83412f
C486 dq6/CLK dq4/a_27_47# 0.02678f
C487 w_2846_27270# a_4654_26861# 0.08866f
C488 xq5/A xq5/VPB 0.21072f
C489 dff5/a_193_47# dff5/D 0.05082f
C490 xq4/A xq3/A 3.93592f
C491 xq0/A dq0/a_27_47# 0.05395f
C492 RD3/R1_5 RD4/R1_1 0.05012f
C493 RD0/R2_2 CM1/C1 0.01627f
C494 dff6/CLK dff4/D 0.53376f
C495 xq0/X xq1/X 8.97165f
C496 a_520_37976# CM1/C2 0.11109f
C497 xq4/A xq1/A 0.42539f
C498 a_3032_26237# a_2306_26380# 0.42401f
C499 xq0/A xq3/A 0.59314f
C500 xq5/A dq5/a_634_159# 0.01899f
C501 dff6/a_891_413# dff3/D 0.03082f
C502 dff2/a_27_47# xq1/VPB 0.05525f
C503 dq3/a_891_413# dq2/a_891_413# 0.01464f
C504 dq6/CLK dq0/a_27_47# 0.02515f
C505 xq0/A dff6/a_27_47# 0.02028f
C506 xq0/A xq1/A 3.26564f
C507 dff6/CLK dff4/a_27_47# 0.09252f
C508 a_4654_26861# CM1/C2 2.5041f
C509 dff5/a_1062_300# xq4/A 0.03254f
C510 dq6/CLK xq3/A 0.53983f
C511 dff1/a_475_413# dff3/D 0.02248f
C512 xq5/A xq4/A 3.83212f
C513 dff5/a_1062_300# xq0/A 0.02077f
C514 dq6/CLK xq1/A 0.3522f
C515 dff6/CLK dff3/D 0.04613f
C516 xq2/A xq4/A 0.06094f
C517 xq5/A xq0/A 0.09259f
C518 dq1/a_466_413# dq0/a_466_413# 0.01384f
C519 dq4/a_466_413# xq4/A 0.0151f
C520 mon/A dff1/D 0.25919f
C521 dff4/D mon/X 0.12115f
C522 xq0/A xq2/A 0.24294f
C523 mon/A a_586_39570# 0.18645f
C524 dq4/a_381_47# xq4/A 0.01377f
C525 dff1/a_27_47# dff3/D 0.05521f
C526 xq5/A dq6/CLK 0.80173f
C527 xq4/B xq5/B 0.02433f
C528 dff2/a_193_47# dff4/D 0.0554f
C529 dq6/CLK xq2/A 0.41073f
C530 xq6/a_285_297# xq6/X 0.0186f
C531 dff3/a_27_47# dff3/a_193_47# -0.01246f
C532 dff6/CLK dff2/a_891_413# 0.02687f
C533 mon/A mon/a_27_47# 0.0521f
C534 RD6/R2_2 CM1/C1 0.01627f
C535 xq1/B dq1/a_1059_315# 0.02886f
C536 xq0/A dq0/a_891_413# 0.02207f
C537 dff1/a_193_47# dff3/D 0.06104f
C538 xq0/a_35_297# xq1/a_35_297# 0.01441f
C539 dff6/CLK dff2/D 0.37947f
C540 xq4/X xq2/X 0.10668f
C541 a_1066_39096# dff4/D 0.0905f
C542 xq5/X xq2/X 0.10411f
C543 dq1/a_1059_315# dq0/a_1059_315# 0.02605f
C544 dff6/D xq0/A 0.08148f
C545 a_2306_26380# a_1906_26237# 0.3085f
C546 dff6/D w_440_39556# 0.34745f
C547 dff0/a_193_47# dff0/a_27_47# -0.01246f
C548 xq6/B xq6/VPB 0.03493f
C549 xq3/X xq2/X 7.73238f
C550 xq0/A dff5/a_27_47# 0.0139f
C551 dff1/D dff1/a_381_47# 0.01227f
C552 xq3/B xq3/a_35_297# 0.17659f
C553 a_1066_39096# dff3/D 0.10762f
C554 dff2/D mon/X 0.08268f
C555 xq3/VPB dff5/D 0.16441f
C556 dff3/a_27_47# xq1/VPB 0.05763f
C557 dq6/a_381_47# xq6/A 0.01362f
C558 dff2/a_193_47# dff2/D 0.08276f
C559 xq5/VPB xq6/VPB 0.02013f
C560 xq2/X xq6/X 0.10665f
C561 xq0/X CM1/C1 2.35994f
C562 xq1/VPB dq1/a_27_47# 0.0501f
C563 xq5/A dq5/a_193_47# 0.07871f
C564 mon/a_27_47# dff0/a_1062_300# 0.01029f
C565 xq1/A dq0/a_193_47# 0.01279f
C566 dq6/a_193_47# dq5/a_193_47# 0.0272f
C567 dff6/D dff6/a_381_47# 0.01244f
C568 xq0/a_35_297# xq0/B 0.17659f
C569 xq3/VPB xq6/A 0.04247f
C570 xq1/A dq1/a_466_413# 0.01667f
C571 a_1066_39096# dff2/D 0.10842f
C572 dq1/a_27_47# dq0/a_27_47# 0.03757f
C573 dff3/a_27_47# xq3/A 0.01249f
C574 dff6/a_27_47# dff0/a_1062_300# 0.01014f
C575 dff6/D mon/A 0.13353f
C576 dff3/a_27_47# xq1/A 0.01104f
C577 xq2/A dq2/a_466_413# 0.01539f
C578 dff6/a_634_183# dff6/CLK 0.01946f
C579 xq4/B xq5/VPB 0.03413f
C580 xq1/A dq1/a_27_47# 0.0615f
C581 RD2/R2_4 CM1/C1 0.01655f
C582 xq1/VPB dff2/a_1062_300# 0.02498f
C583 dq6/CLK xq6/VPB 0.10719f
C584 xq0/A dff6/CLK 1.0047f
C585 xq5/A dff3/a_27_47# 0.01026f
C586 a_4654_26861# RIN/B 2.97969f
C587 a_1906_26237# RIN/B 2.92238f
C588 a_2306_26380# RIN/B 1.54242f
C589 a_3032_26237# RIN/B 3.35237f
C590 a_3032_27474# RIN/B 1.10693f
C591 a_520_37976# RIN/B 0.35628f
C592 a_1066_39096# RIN/B 5.04505f
C593 a_586_39570# RIN/B 2.34816f
C594 w_2846_27270# RIN/B 10.92023f
C595 w_440_39556# RIN/B 10.16071f
C596 xq3/X RIN/B 1.53841f
C597 xq3/a_35_297# RIN/B 0.25274f
C598 xq1/A RIN/B 1.68262f
C599 dff1/D RIN/B 2.44967f
C600 xq3/VPB RIN/B 13.61486f
C601 dff1/a_381_47# RIN/B 0.0164f
C602 dff1/a_891_413# RIN/B 0.1612f
C603 dff1/a_1062_300# RIN/B 0.53253f
C604 dff1/a_475_413# RIN/B 0.13738f
C605 dff1/a_634_183# RIN/B 0.15022f
C606 dff1/a_193_47# RIN/B 0.27169f
C607 dff1/a_27_47# RIN/B 0.49817f
C608 RD6/R1_5 RIN/B 0.6195f
C609 RD6/R2_4 RIN/B 0.39779f
C610 RD6/R1_3 RIN/B 0.39753f
C611 RD6/R2_2 RIN/B 0.39779f
C612 RD6/R1_1 RIN/B 0.56382f
C613 xq2/a_35_297# RIN/B 0.25274f
C614 xq6/B RIN/B 0.25342f
C615 xq6/VPB RIN/B 6.06325f
C616 xq6/A RIN/B 2.73132f
C617 dq6/a_381_47# RIN/B 0.01537f
C618 dq6/a_891_413# RIN/B 0.16087f
C619 dq6/a_1059_315# RIN/B 0.24994f
C620 dq6/a_466_413# RIN/B 0.13324f
C621 dq6/a_634_159# RIN/B 0.14231f
C622 dq6/a_193_47# RIN/B 0.27323f
C623 dq6/a_27_47# RIN/B 0.47896f
C624 xq0/A RIN/B 3.47207f
C625 mon/A RIN/B 3.48695f
C626 dff6/CLK RIN/B 3.5041f
C627 dff0/a_381_47# RIN/B 0.0164f
C628 dff0/a_891_413# RIN/B 0.1612f
C629 dff0/a_1062_300# RIN/B 0.53158f
C630 dff0/a_475_413# RIN/B 0.13739f
C631 dff0/a_634_183# RIN/B 0.1503f
C632 dff0/a_193_47# RIN/B 0.27167f
C633 dff0/a_27_47# RIN/B 0.49858f
C634 RD5/R1_5 RIN/B 0.56382f
C635 RD5/R2_4 RIN/B 0.39779f
C636 RD5/R1_3 RIN/B 0.39753f
C637 RD5/R2_2 RIN/B 0.39779f
C638 RD5/R1_1 RIN/B 0.56382f
C639 xq1/a_35_297# RIN/B 0.25274f
C640 xq5/B RIN/B 0.24031f
C641 xq5/VPB RIN/B 6.79005f
C642 xq5/A RIN/B 1.82816f
C643 dq6/CLK RIN/B 6.85464f
C644 dq5/a_381_47# RIN/B 0.01537f
C645 dq5/a_891_413# RIN/B 0.16087f
C646 dq5/a_1059_315# RIN/B 0.24994f
C647 dq5/a_466_413# RIN/B 0.13324f
C648 dq5/a_634_159# RIN/B 0.14231f
C649 dq5/a_193_47# RIN/B 0.27323f
C650 dq5/a_27_47# RIN/B 0.47896f
C651 RD4/R1_5 RIN/B 0.56382f
C652 RD4/R2_4 RIN/B 0.39779f
C653 RD4/R1_3 RIN/B 0.39753f
C654 RD4/R2_2 RIN/B 0.39779f
C655 RD4/R1_1 RIN/B 0.56382f
C656 RD3/R1_5 RIN/B 0.56382f
C657 RD3/R2_4 RIN/B 0.39779f
C658 RD3/R1_3 RIN/B 0.39753f
C659 RD3/R2_2 RIN/B 0.39779f
C660 RD3/R1_1 RIN/B 0.56382f
C661 xq0/a_35_297# RIN/B 0.25292f
C662 xq4/B RIN/B 0.24031f
C663 xq4/A RIN/B 1.44321f
C664 dq4/a_381_47# RIN/B 0.01537f
C665 dq4/a_891_413# RIN/B 0.16087f
C666 dq4/a_1059_315# RIN/B 0.24994f
C667 dq4/a_466_413# RIN/B 0.13324f
C668 dq4/a_634_159# RIN/B 0.14231f
C669 dq4/a_193_47# RIN/B 0.27323f
C670 dq4/a_27_47# RIN/B 0.47896f
C671 RD2/R1_5 RIN/B 0.56382f
C672 RD2/R2_4 RIN/B 0.39779f
C673 RD2/R1_3 RIN/B 0.39753f
C674 RD2/R2_2 RIN/B 0.39779f
C675 xq2/X RIN/B 1.34863f
C676 RD2/R1_1 RIN/B 0.56326f
C677 xq3/B RIN/B 0.24031f
C678 xq3/A RIN/B 1.569f
C679 dq3/a_381_47# RIN/B 0.01537f
C680 dq3/a_891_413# RIN/B 0.16087f
C681 dq3/a_1059_315# RIN/B 0.24994f
C682 dq3/a_466_413# RIN/B 0.13324f
C683 dq3/a_634_159# RIN/B 0.14231f
C684 dq3/a_193_47# RIN/B 0.27323f
C685 dq3/a_27_47# RIN/B 0.47896f
C686 RD1/R1_5 RIN/B 0.55914f
C687 RD1/R2_4 RIN/B 0.39779f
C688 RD1/R1_3 RIN/B 0.39345f
C689 RD1/R2_2 RIN/B 0.39779f
C690 xq1/X RIN/B 1.40759f
C691 RD1/R1_1 RIN/B 0.56018f
C692 xq2/B RIN/B 0.24031f
C693 dq2/a_381_47# RIN/B 0.01537f
C694 dq2/a_891_413# RIN/B 0.16087f
C695 dq2/a_1059_315# RIN/B 0.24994f
C696 dq2/a_466_413# RIN/B 0.13324f
C697 dq2/a_634_159# RIN/B 0.14231f
C698 dq2/a_193_47# RIN/B 0.27323f
C699 dq2/a_27_47# RIN/B 0.47896f
C700 RD0/R1_5 RIN/B 0.55879f
C701 RD0/R2_4 RIN/B 0.39779f
C702 RD0/R1_3 RIN/B 0.39577f
C703 RD0/R2_2 RIN/B 0.39779f
C704 xq0/X RIN/B 1.59901f
C705 RD0/R1_1 RIN/B 0.6153f
C706 xq1/B RIN/B 0.24031f
C707 dq1/a_381_47# RIN/B 0.01537f
C708 dq1/a_891_413# RIN/B 0.16087f
C709 dq1/a_1059_315# RIN/B 0.24994f
C710 dq1/a_466_413# RIN/B 0.13324f
C711 dq1/a_634_159# RIN/B 0.14231f
C712 dq1/a_193_47# RIN/B 0.27323f
C713 dq1/a_27_47# RIN/B 0.47896f
C714 xq0/B RIN/B 0.25472f
C715 dq0/a_381_47# RIN/B 0.01537f
C716 dq0/a_891_413# RIN/B 0.16105f
C717 dq0/a_1059_315# RIN/B 0.2502f
C718 dq0/a_466_413# RIN/B 0.1332f
C719 dq0/a_634_159# RIN/B 0.14231f
C720 dq0/a_193_47# RIN/B 0.27359f
C721 dq0/a_27_47# RIN/B 0.4793f
C722 CM1/C1 RIN/B 16.24994f
C723 CM1/C2 RIN/B 28.56237f
C724 mon/X RIN/B 0.54823f
C725 mon/a_27_47# RIN/B 0.49783f
C726 RIN/R2_0 RIN/B 4.36841f
C727 RIN/R1_1 RIN/B 0.82477f
C728 xq2/A RIN/B 1.46187f
C729 dff6/D RIN/B 2.59894f
C730 dff6/a_381_47# RIN/B 0.0164f
C731 dff6/a_891_413# RIN/B 0.16063f
C732 dff6/a_1062_300# RIN/B 0.53288f
C733 dff6/a_475_413# RIN/B 0.13736f
C734 dff6/a_634_183# RIN/B 0.15128f
C735 dff6/a_193_47# RIN/B 0.27239f
C736 dff6/a_27_47# RIN/B 0.49969f
C737 dff5/D RIN/B 4.42463f
C738 dff5/a_381_47# RIN/B 0.0164f
C739 dff5/a_891_413# RIN/B 0.16096f
C740 dff5/a_1062_300# RIN/B 0.5326f
C741 dff5/a_475_413# RIN/B 0.13733f
C742 dff5/a_634_183# RIN/B 0.15031f
C743 dff5/a_193_47# RIN/B 0.27187f
C744 dff5/a_27_47# RIN/B 0.4981f
C745 dff4/D RIN/B 3.14699f
C746 dff4/a_381_47# RIN/B 0.0164f
C747 dff4/a_891_413# RIN/B 0.16094f
C748 dff4/a_1062_300# RIN/B 0.53148f
C749 dff4/a_475_413# RIN/B 0.13733f
C750 dff4/a_634_183# RIN/B 0.15031f
C751 dff4/a_193_47# RIN/B 0.27176f
C752 dff4/a_27_47# RIN/B 0.49809f
C753 xq6/X RIN/B 3.86873f
C754 xq6/a_35_297# RIN/B 0.25274f
C755 dff3/D RIN/B 2.69764f
C756 dff3/a_381_47# RIN/B 0.0164f
C757 dff3/a_891_413# RIN/B 0.16094f
C758 dff3/a_1062_300# RIN/B 0.53243f
C759 dff3/a_475_413# RIN/B 0.13775f
C760 dff3/a_634_183# RIN/B 0.15014f
C761 dff3/a_193_47# RIN/B 0.27154f
C762 dff3/a_27_47# RIN/B 0.49817f
C763 xq5/X RIN/B 0.69303f
C764 xq5/a_35_297# RIN/B 0.25274f
C765 dff2/D RIN/B 2.56453f
C766 dff2/a_381_47# RIN/B 0.0164f
C767 dff2/a_891_413# RIN/B 0.16098f
C768 dff2/a_1062_300# RIN/B 0.53165f
C769 dff2/a_475_413# RIN/B 0.13757f
C770 dff2/a_634_183# RIN/B 0.15019f
C771 dff2/a_193_47# RIN/B 0.27266f
C772 dff2/a_27_47# RIN/B 0.49836f
C773 xq1/VPB RIN/B 14.61262f
C774 xq4/X RIN/B 1.49257f
C775 xq4/a_35_297# RIN/B 0.25274f
.ends

.subckt sky130_fd_sc_hd__inv_1 VPB VNB VGND VPWR A Y
X0 Y A VGND VNB sky130_fd_pr__nfet_01v8 ad=0.169 pd=1.82 as=0.169 ps=1.82 w=0.65 l=0.15
X1 Y A VPWR VPB sky130_fd_pr__pfet_01v8_hvt ad=0.26 pd=2.52 as=0.26 ps=2.52 w=1 l=0.15
C0 VPB Y 0.01774f
C1 Y VGND 0.09984f
C2 A VPWR 0.03703f
C3 VPB VPWR 0.05448f
C4 VGND VPWR 0.03382f
C5 VPB A 0.04506f
C6 A VGND 0.04004f
C7 Y VPWR 0.12758f
C8 Y A 0.0476f
C9 VGND VNB 0.25113f
C10 Y VNB 0.0961f
C11 VPWR VNB 0.21892f
C12 A VNB 0.16664f
C13 VPB VNB 0.33898f
.ends

.subckt tt_um_arcadia1_vco_adc clk ena rst_n ua[0] ua[1] ua[2] ua[3] ua[4] ua[5] ua[6]
+ ua[7] ui_in[0] ui_in[1] ui_in[2] ui_in[3] ui_in[4] ui_in[5] ui_in[6] ui_in[7] uio_in[0]
+ uio_in[1] uio_in[2] uio_in[3] uio_in[4] uio_in[5] uio_in[6] uio_in[7] uio_out[0]
+ uio_out[1] uio_out[2] uio_out[3] uio_out[4] uio_out[5] uio_out[6] uio_out[7] uo_out[0]
+ uo_out[1] uo_out[2] uo_out[3] uo_out[4] uo_out[5] uo_out[6] uo_out[7] VGND VDPWR
XRT RT/R1_5 RT/R1_3 RT/R1_3 RT/R1_1 RT/R1_1 VGND RT/R2_7 RT/R2_6 RT/R2_6 RT/R2_4 RT/R2_4
+ RT/R2_2 RT/R2_2 VDPWR RT/R1_7 RT/R1_7 RT/R1_5 sky130_fd_pr__res_xhigh_po_0p35_4MFQX6
XRARR VGND RARR/R1_3 VGND RARR/R1_1 VGND VGND VGND RARR/R2_4 RARR/R2_3 RARR/R2_3 RARR/R2_4
+ VGND VGND sky130_fd_pr__res_xhigh_po_0p35_JUTA22
XRB RB/R1_3 RB/R1_3 RB/R1_1 RB/R1_1 VGND RB/R2_3 RB/R2_2 RB/R2_2 VDPWR sky130_fd_pr__res_xhigh_po_0p35_V6BCNG
XhalfN irst/Y halfN/mon/A halfN/xq3/X halfN/CM1/C1 RARR/R1_1 RB/R2_3 VDPWR halfN/a_586_39570#
+ uio_out[5] RT/R2_7 uio_out[7] VGND uio_out[0] VDPWR halfN/xq4/X VDPWR clk VDPWR
+ halfN/xq6/X halfN/CM1/C2 clk halfN/dff5/D uio_out[2] uio_out[6] uio_out[1] uio_out[3]
+ VDPWR halfN/xq5/X ua[1] halfN/dff4/D uio_out[4] VGND VDPWR vco_adc_half
XhalfP irst/Y halfP/mon/A halfP/xq3/X halfP/CM1/C1 RARR/R1_3 RB/R2_3 VDPWR halfP/a_586_39570#
+ uo_out[2] RT/R2_7 uo_out[0] VGND uo_out[7] VDPWR halfP/xq4/X VDPWR clk VDPWR halfP/xq6/X
+ halfP/CM1/C2 clk halfP/dff5/D uo_out[5] uo_out[1] uo_out[6] uo_out[4] VDPWR halfP/xq5/X
+ ua[0] halfP/dff4/D uo_out[3] VGND VDPWR vco_adc_half
Xirst VDPWR VGND VGND VDPWR rst_n irst/Y sky130_fd_sc_hd__inv_1
XRBT RBT/R1_5 RBT/R1_3 RBT/R1_3 RBT/R1_1 RBT/R1_1 VGND VGND RBT/R2_6 RBT/R2_6 RBT/R2_4
+ RBT/R2_4 RBT/R2_2 RBT/R2_2 RT/R2_7 RBT/R1_7 RBT/R1_7 RBT/R1_5 sky130_fd_pr__res_xhigh_po_0p35_4MFQX6
X0 VGND RB/R2_3 RB/R2_3 VGND sky130_fd_pr__nfet_01v8 ad=0.66 pd=4.66 as=0.37 ps=2.37 w=2 l=2
X1 VGND RT/R2_7 VGND VGND sky130_fd_pr__nfet_01v8 ad=1.65 pd=10.66 as=52.25745 ps=493.85999 w=5 l=10
X2 RB/R2_3 RB/R2_3 VGND VGND sky130_fd_pr__nfet_01v8 ad=0.37 pd=2.37 as=0.66 ps=4.66 w=2 l=2
X3 VGND RT/R2_7 VGND VGND sky130_fd_pr__nfet_01v8 ad=0.925 pd=5.37 as=0 ps=0 w=5 l=10
C0 uio_in[7] uio_in[6] 0.03102f
C1 halfN/CM1/C2 RARR/R1_1 0.01462f
C2 rst_n halfP/xq0/X 0.01872f
C3 VDPWR halfN/xq4/X 0.03961f
C4 uo_out[6] clk 0.12527f
C5 RB/R2_2 RB/R2_3 0.01866f
C6 uo_out[4] clk 0.04242f
C7 halfP/CM1/C2 RT/R1_3 0.01305f
C8 halfP/CM1/C2 ua[1] 0.01272f
C9 RT/R1_1 rst_n 0.04969f
C10 rst_n halfP/xq6/X 0.89938f
C11 uio_in[5] uio_in[6] 0.03102f
C12 RT/R1_3 ua[1] 0.01085f
C13 VDPWR halfP/dff5/D 0.01225f
C14 ua[1] ua[0] 0.03671f
C15 RB/R2_3 irst/Y 1.2307f
C16 RARR/R1_3 halfP/CM1/C2 0.01191f
C17 ui_in[7] ui_in[6] 0.03102f
C18 ui_in[6] ui_in[5] 0.03102f
C19 VDPWR halfN/xq3/X 0.03075f
C20 uio_in[4] uio_in[5] 0.03102f
C21 halfN/CM1/C1 ua[1] 0.02078f
C22 halfN/xq5/X VDPWR 0.06883f
C23 RT/R2_6 RT/R2_7 0.05628f
C24 rst_n RT/R1_5 0.04338f
C25 rst_n halfP/CM1/C1 0.03883f
C26 rst_n RBT/R1_5 0.04338f
C27 VDPWR RB/R2_3 0.08888f
C28 rst_n halfP/xq5/X 0.17644f
C29 halfP/CM1/C2 RT/R1_1 0.01305f
C30 rst_n RB/R2_3 0.02658f
C31 VDPWR halfN/xq0/X 0.01153f
C32 RT/R2_7 irst/Y 0.95269f
C33 rst_n halfP/xq4/X 0.08343f
C34 RT/R2_7 RT/R2_4 0.03749f
C35 RT/R1_1 ua[1] 0.01085f
C36 ui_in[3] ui_in[4] 0.03102f
C37 VDPWR uo_out[3] 0.02524f
C38 uio_out[1] uo_out[6] 0.02244f
C39 VDPWR uio_out[7] 0.73129f
C40 uo_out[3] clk 0.01571f
C41 VDPWR RT/R2_7 0.89892f
C42 halfP/CM1/C2 RT/R1_5 0.01305f
C43 uio_out[7] clk -0.01056f
C44 halfP/CM1/C2 RBT/R1_5 0.01305f
C45 halfP/mon/A halfN/mon/A 0.10005f
C46 VDPWR uio_out[4] 0.14402f
C47 rst_n RBT/R1_1 0.04671f
C48 rst_n RBT/R1_3 0.04338f
C49 rst_n RT/R2_7 0.31855f
C50 RT/R1_5 ua[1] 0.01085f
C51 VDPWR halfN/xq2/X 0.02018f
C52 halfP/CM1/C1 ua[1] 0.02055f
C53 RBT/R1_5 ua[1] 0.01085f
C54 VDPWR uio_out[3] 0.17441f
C55 RT/R1_7 RBT/R1_1 0.04565f
C56 VDPWR uio_out[5] 0.14592f
C57 RT/R2_2 RT/R2_7 0.03527f
C58 RB/R2_3 ua[1] 0.4699f
C59 VDPWR uio_out[6] 0.16702f
C60 uo_out[5] clk 0.0201f
C61 uo_out[7] clk 0.01445f
C62 RB/R1_1 ua[1] 0.05418f
C63 RBT/R2_4 VDPWR 0.01631f
C64 uio_out[0] uo_out[7] 0.51433f
C65 halfP/CM1/C2 RBT/R1_1 0.01305f
C66 halfP/CM1/C2 RBT/R1_3 0.01305f
C67 VDPWR RBT/R2_6 0.01631f
C68 RBT/R1_1 ua[1] 0.01085f
C69 RBT/R1_3 ua[1] 0.01085f
C70 RT/R2_7 ua[1] 0.39686f
C71 rst_n halfP/xq3/X 0.05345f
C72 RT/R2_6 VDPWR 0.01632f
C73 RB/R2_2 VDPWR 0.01663f
C74 ui_in[5] ui_in[4] 0.03102f
C75 halfP/CM1/C2 halfN/CM1/C2 0.50085f
C76 clk uo_out[1] 0.02749f
C77 uo_out[0] uio_in[7] 0.03274f
C78 halfN/CM1/C2 ua[1] 0.82425f
C79 RARR/R1_3 RARR/R1_1 0.0619f
C80 VDPWR irst/Y 0.24084f
C81 uio_in[4] uio_in[3] 0.03102f
C82 ui_in[1] ui_in[2] 0.03102f
C83 VDPWR RT/R2_4 0.01635f
C84 VDPWR RBT/R2_2 0.01631f
C85 VDPWR uio_out[2] 0.15598f
C86 ui_in[3] ui_in[2] 0.03102f
C87 ua[1] RB/R1_3 0.05418f
C88 rst_n irst/Y 0.18658f
C89 VDPWR halfN/dff5/D 0.01225f
C90 VDPWR halfN/xq1/X 0.01713f
C91 uio_in[1] uio_in[0] 0.03102f
C92 VDPWR uo_out[2] 0.02713f
C93 VDPWR rst_n 0.41505f
C94 VDPWR clk 0.81983f
C95 ena clk 0.03102f
C96 clk uo_out[2] 0.01288f
C97 ui_in[0] rst_n 0.03102f
C98 rst_n clk 0.19099f
C99 VDPWR RT/R2_2 0.01663f
C100 uio_in[1] uio_in[2] 0.03102f
C101 uio_out[0] clk 0.01445f
C102 RT/R1_7 rst_n 0.04671f
C103 RBT/R1_7 rst_n 0.04853f
C104 uio_in[3] uio_in[2] 0.03102f
C105 ui_in[7] uio_in[0] 0.03102f
C106 halfP/xq2/X rst_n 0.03421f
C107 uo_out[0] clk 0.10094f
C108 ua[1] irst/Y 0.65176f
C109 RB/R2_3 RT/R2_7 1.74637f
C110 ui_in[1] ui_in[0] 0.03102f
C111 VDPWR ua[1] 1.51738f
C112 halfP/CM1/C2 rst_n 1.08429f
C113 VDPWR ua[0] 2.98252f
C114 rst_n RT/R1_3 0.04422f
C115 rst_n ua[1] 3.22582f
C116 halfP/CM1/C2 RT/R1_7 0.01305f
C117 uio_out[1] VDPWR 0.25349f
C118 halfP/CM1/C2 RBT/R1_7 0.01305f
C119 rst_n ua[0] 1.20019f
C120 RT/R1_7 ua[1] 0.01085f
C121 RARR/R2_4 RARR/R2_3 0.12578f
C122 RBT/R1_7 ua[1] 0.01085f
C123 halfP/xq1/X rst_n 0.02603f
C124 VDPWR uo_out[6] 0.05092f
C125 VDPWR halfN/xq6/X 0.3021f
C126 ua[2] VGND 0.14723f
C127 ua[3] VGND 0.14723f
C128 ua[4] VGND 0.14723f
C129 ua[5] VGND 0.14723f
C130 ua[6] VGND 0.14723f
C131 ua[7] VGND 0.14723f
C132 ena VGND 0.07059f
C133 ui_in[0] VGND 0.04301f
C134 ui_in[1] VGND 0.04301f
C135 ui_in[2] VGND 0.04307f
C136 ui_in[3] VGND 0.04307f
C137 ui_in[4] VGND 0.04307f
C138 ui_in[5] VGND 0.04329f
C139 ui_in[6] VGND 0.04301f
C140 ui_in[7] VGND 0.04301f
C141 uio_in[0] VGND 0.04301f
C142 uio_in[1] VGND 0.04301f
C143 uio_in[2] VGND 0.04301f
C144 uio_in[3] VGND 0.04301f
C145 uio_in[4] VGND 0.04301f
C146 uio_in[5] VGND 0.04301f
C147 uio_in[6] VGND 0.04301f
C148 uio_in[7] VGND 0.04301f
C149 RBT/R1_7 VGND 0.60865f
C150 RBT/R2_6 VGND 0.37658f
C151 RBT/R1_5 VGND 0.38618f
C152 RBT/R2_4 VGND 0.37059f
C153 RBT/R1_3 VGND 0.38618f
C154 RBT/R2_2 VGND 0.36973f
C155 RBT/R1_1 VGND 0.55583f
C156 irst/Y VGND 6.78188f
C157 rst_n VGND 1.13124f
C158 halfP/a_2306_26380# VGND 1.54242f $ **FLOATING
C159 halfP/a_3032_27474# VGND 1.1053f $ **FLOATING
C160 halfP/a_1066_39096# VGND 5.05355f $ **FLOATING
C161 halfP/a_586_39570# VGND 2.359f
C162 halfP/xq3/X VGND 1.38408f
C163 halfP/xq3/a_35_297# VGND 0.25457f
C164 uo_out[2] VGND 1.23408f
C165 halfP/dff1/D VGND 2.34494f
C166 halfP/dff1/a_381_47# VGND 0.0164f
C167 halfP/dff1/a_891_413# VGND 0.16089f
C168 halfP/dff1/a_1062_300# VGND 0.52966f
C169 halfP/dff1/a_475_413# VGND 0.13718f
C170 halfP/dff1/a_634_183# VGND 0.15021f
C171 halfP/dff1/a_193_47# VGND 0.27118f
C172 halfP/dff1/a_27_47# VGND 0.4683f
C173 halfP/RD6/R1_5 VGND 0.61861f
C174 halfP/RD6/R2_4 VGND 0.39677f
C175 halfP/RD6/R1_3 VGND 0.39666f
C176 halfP/RD6/R2_2 VGND 0.39677f
C177 halfP/RD6/R1_1 VGND 0.56073f
C178 halfP/xq2/a_35_297# VGND 0.25457f
C179 halfP/xq6/B VGND 0.19993f
C180 uo_out[0] VGND 2.18805f
C181 halfP/dq6/a_381_47# VGND 0.01537f
C182 halfP/dq6/a_891_413# VGND 0.16105f
C183 halfP/dq6/a_1059_315# VGND 0.24885f
C184 halfP/dq6/a_466_413# VGND 0.1332f
C185 halfP/dq6/a_634_159# VGND 0.14231f
C186 halfP/dq6/a_193_47# VGND 0.28426f
C187 halfP/dq6/a_27_47# VGND 0.44951f
C188 uo_out[6] VGND 1.53461f
C189 halfP/mon/A VGND 3.27388f
C190 clk VGND 15.30977f
C191 halfP/dff0/a_381_47# VGND 0.0164f
C192 halfP/dff0/a_891_413# VGND 0.16089f
C193 halfP/dff0/a_1062_300# VGND 0.52966f
C194 halfP/dff0/a_475_413# VGND 0.13718f
C195 halfP/dff0/a_634_183# VGND 0.15021f
C196 halfP/dff0/a_193_47# VGND 0.27134f
C197 halfP/dff0/a_27_47# VGND 0.46838f
C198 halfP/RD5/R1_5 VGND 0.56073f
C199 halfP/RD5/R2_4 VGND 0.39677f
C200 halfP/RD5/R1_3 VGND 0.39666f
C201 halfP/RD5/R2_2 VGND 0.39677f
C202 halfP/RD5/R1_1 VGND 0.56073f
C203 halfP/xq1/a_35_297# VGND 0.25457f
C204 halfP/xq5/B VGND 0.18682f
C205 uo_out[4] VGND 1.43409f
C206 halfP/dq5/a_381_47# VGND 0.01537f
C207 halfP/dq5/a_891_413# VGND 0.16105f
C208 halfP/dq5/a_1059_315# VGND 0.24885f
C209 halfP/dq5/a_466_413# VGND 0.1332f
C210 halfP/dq5/a_634_159# VGND 0.14231f
C211 halfP/dq5/a_193_47# VGND 0.28426f
C212 halfP/dq5/a_27_47# VGND 0.44951f
C213 halfP/RD4/R1_5 VGND 0.56073f
C214 halfP/RD4/R2_4 VGND 0.39677f
C215 halfP/RD4/R1_3 VGND 0.39666f
C216 halfP/RD4/R2_2 VGND 0.39677f
C217 halfP/RD4/R1_1 VGND 0.56073f
C218 halfP/RD3/R1_5 VGND 0.56073f
C219 halfP/RD3/R2_4 VGND 0.39677f
C220 halfP/RD3/R1_3 VGND 0.39666f
C221 halfP/RD3/R2_2 VGND 0.39677f
C222 halfP/RD3/R1_1 VGND 0.56073f
C223 halfP/xq0/a_35_297# VGND 0.25457f
C224 halfP/xq4/B VGND 0.18682f
C225 uo_out[1] VGND 1.03842f
C226 halfP/dq4/a_381_47# VGND 0.01537f
C227 halfP/dq4/a_891_413# VGND 0.16105f
C228 halfP/dq4/a_1059_315# VGND 0.24885f
C229 halfP/dq4/a_466_413# VGND 0.1332f
C230 halfP/dq4/a_634_159# VGND 0.14231f
C231 halfP/dq4/a_193_47# VGND 0.28426f
C232 halfP/dq4/a_27_47# VGND 0.44951f
C233 halfP/RD2/R1_5 VGND 0.56073f
C234 halfP/RD2/R2_4 VGND 0.39677f
C235 halfP/RD2/R1_3 VGND 0.40562f
C236 halfP/RD2/R2_2 VGND 0.39677f
C237 halfP/xq2/X VGND 1.21156f
C238 halfP/RD2/R1_1 VGND 0.56158f
C239 halfP/xq3/B VGND 0.18682f
C240 uo_out[5] VGND 1.19459f
C241 halfP/dq3/a_381_47# VGND 0.01537f
C242 halfP/dq3/a_891_413# VGND 0.16105f
C243 halfP/dq3/a_1059_315# VGND 0.24885f
C244 halfP/dq3/a_466_413# VGND 0.1332f
C245 halfP/dq3/a_634_159# VGND 0.14231f
C246 halfP/dq3/a_193_47# VGND 0.28426f
C247 halfP/dq3/a_27_47# VGND 0.44951f
C248 halfP/RD1/R1_5 VGND 0.55581f
C249 halfP/RD1/R2_4 VGND 0.39677f
C250 halfP/RD1/R1_3 VGND 0.39236f
C251 halfP/RD1/R2_2 VGND 0.39677f
C252 halfP/xq1/X VGND 1.21835f
C253 halfP/RD1/R1_1 VGND 0.5568f
C254 halfP/xq2/B VGND 0.18682f
C255 halfP/dq2/a_381_47# VGND 0.01537f
C256 halfP/dq2/a_891_413# VGND 0.16105f
C257 halfP/dq2/a_1059_315# VGND 0.24885f
C258 halfP/dq2/a_466_413# VGND 0.1332f
C259 halfP/dq2/a_634_159# VGND 0.14231f
C260 halfP/dq2/a_193_47# VGND 0.28426f
C261 halfP/dq2/a_27_47# VGND 0.44951f
C262 halfP/RD0/R1_5 VGND 0.55546f
C263 halfP/RD0/R2_4 VGND 0.39677f
C264 halfP/RD0/R1_3 VGND 0.39458f
C265 halfP/RD0/R2_2 VGND 0.39677f
C266 halfP/xq0/X VGND 1.29597f
C267 halfP/RD0/R1_1 VGND 0.61415f
C268 halfP/xq1/B VGND 0.18682f
C269 halfP/dq1/a_381_47# VGND 0.01537f
C270 halfP/dq1/a_891_413# VGND 0.16105f
C271 halfP/dq1/a_1059_315# VGND 0.24885f
C272 halfP/dq1/a_466_413# VGND 0.1332f
C273 halfP/dq1/a_634_159# VGND 0.14231f
C274 halfP/dq1/a_193_47# VGND 0.28426f
C275 halfP/dq1/a_27_47# VGND 0.44951f
C276 halfP/xq0/B VGND 0.20094f
C277 halfP/dq0/a_381_47# VGND 0.01537f
C278 halfP/dq0/a_891_413# VGND 0.16105f
C279 halfP/dq0/a_1059_315# VGND 0.24885f
C280 halfP/dq0/a_466_413# VGND 0.1332f
C281 halfP/dq0/a_634_159# VGND 0.14231f
C282 halfP/dq0/a_193_47# VGND 0.28426f
C283 halfP/dq0/a_27_47# VGND 0.44951f
C284 halfP/CM1/C1 VGND 15.614f
C285 halfP/CM1/C2 VGND 28.21861f
C286 uo_out[7] VGND 0.06158f
C287 halfP/mon/a_27_47# VGND 0.46147f
C288 ua[0] VGND 9.69646f
C289 halfP/RIN/R1_1 VGND 0.82178f
C290 uo_out[3] VGND 1.02521f
C291 halfP/dff6/D VGND 2.47015f
C292 halfP/dff6/a_381_47# VGND 0.0164f
C293 halfP/dff6/a_891_413# VGND 0.16089f
C294 halfP/dff6/a_1062_300# VGND 0.52966f
C295 halfP/dff6/a_475_413# VGND 0.13718f
C296 halfP/dff6/a_634_183# VGND 0.15021f
C297 halfP/dff6/a_193_47# VGND 0.27118f
C298 halfP/dff6/a_27_47# VGND 0.4683f
C299 halfP/dff5/D VGND 4.07731f
C300 halfP/dff5/a_381_47# VGND 0.0164f
C301 halfP/dff5/a_891_413# VGND 0.16089f
C302 halfP/dff5/a_1062_300# VGND 0.52993f
C303 halfP/dff5/a_475_413# VGND 0.13718f
C304 halfP/dff5/a_634_183# VGND 0.15021f
C305 halfP/dff5/a_193_47# VGND 0.27118f
C306 halfP/dff5/a_27_47# VGND 0.4683f
C307 halfP/dff4/D VGND 2.82023f
C308 halfP/dff4/a_381_47# VGND 0.0164f
C309 halfP/dff4/a_891_413# VGND 0.16089f
C310 halfP/dff4/a_1062_300# VGND 0.52966f
C311 halfP/dff4/a_475_413# VGND 0.13718f
C312 halfP/dff4/a_634_183# VGND 0.15021f
C313 halfP/dff4/a_193_47# VGND 0.27119f
C314 halfP/dff4/a_27_47# VGND 0.4683f
C315 halfP/xq6/X VGND 3.78998f
C316 halfP/xq6/a_35_297# VGND 0.25457f
C317 halfP/dff3/D VGND 2.47213f
C318 halfP/dff3/a_381_47# VGND 0.0164f
C319 halfP/dff3/a_891_413# VGND 0.16089f
C320 halfP/dff3/a_1062_300# VGND 0.52966f
C321 halfP/dff3/a_475_413# VGND 0.13718f
C322 halfP/dff3/a_634_183# VGND 0.15021f
C323 halfP/dff3/a_193_47# VGND 0.27118f
C324 halfP/dff3/a_27_47# VGND 0.4683f
C325 halfP/xq5/X VGND 0.56755f
C326 halfP/xq5/a_35_297# VGND 0.25457f
C327 halfP/dff2/D VGND 2.33687f
C328 halfP/dff2/a_381_47# VGND 0.0164f
C329 halfP/dff2/a_891_413# VGND 0.16089f
C330 halfP/dff2/a_1062_300# VGND 0.52966f
C331 halfP/dff2/a_475_413# VGND 0.13718f
C332 halfP/dff2/a_634_183# VGND 0.15021f
C333 halfP/dff2/a_193_47# VGND 0.27123f
C334 halfP/dff2/a_27_47# VGND 0.46832f
C335 halfP/xq4/X VGND 1.38689f
C336 halfP/xq4/a_35_297# VGND 0.25457f
C337 halfN/a_2306_26380# VGND 1.54242f $ **FLOATING
C338 RT/R2_7 VGND 17.37497f
C339 halfN/a_3032_27474# VGND 1.1053f $ **FLOATING
C340 RARR/R1_1 VGND 0.94255f
C341 halfN/a_1066_39096# VGND 5.05355f $ **FLOATING
C342 halfN/a_586_39570# VGND 2.359f
C343 halfN/xq3/X VGND 1.38586f
C344 halfN/xq3/a_35_297# VGND 0.25457f
C345 uio_out[5] VGND 1.22202f
C346 halfN/dff1/D VGND 2.34494f
C347 VDPWR VGND 0.38054p
C348 halfN/dff1/a_381_47# VGND 0.0164f
C349 halfN/dff1/a_891_413# VGND 0.16089f
C350 halfN/dff1/a_1062_300# VGND 0.52966f
C351 halfN/dff1/a_475_413# VGND 0.13718f
C352 halfN/dff1/a_634_183# VGND 0.15021f
C353 halfN/dff1/a_193_47# VGND 0.27118f
C354 halfN/dff1/a_27_47# VGND 0.4683f
C355 halfN/RD6/R1_5 VGND 0.61861f
C356 halfN/RD6/R2_4 VGND 0.39677f
C357 halfN/RD6/R1_3 VGND 0.39666f
C358 halfN/RD6/R2_2 VGND 0.39677f
C359 halfN/RD6/R1_1 VGND 0.56073f
C360 halfN/xq2/a_35_297# VGND 0.25457f
C361 halfN/xq6/B VGND 0.19993f
C362 uio_out[7] VGND 1.99507f
C363 halfN/dq6/a_381_47# VGND 0.01537f
C364 halfN/dq6/a_891_413# VGND 0.16105f
C365 halfN/dq6/a_1059_315# VGND 0.24885f
C366 halfN/dq6/a_466_413# VGND 0.1332f
C367 halfN/dq6/a_634_159# VGND 0.14231f
C368 halfN/dq6/a_193_47# VGND 0.28426f
C369 halfN/dq6/a_27_47# VGND 0.44951f
C370 uio_out[1] VGND 1.522f
C371 halfN/mon/A VGND 3.27388f
C372 halfN/dff0/a_381_47# VGND 0.0164f
C373 halfN/dff0/a_891_413# VGND 0.16089f
C374 halfN/dff0/a_1062_300# VGND 0.52966f
C375 halfN/dff0/a_475_413# VGND 0.13718f
C376 halfN/dff0/a_634_183# VGND 0.15021f
C377 halfN/dff0/a_193_47# VGND 0.27134f
C378 halfN/dff0/a_27_47# VGND 0.46838f
C379 halfN/RD5/R1_5 VGND 0.56073f
C380 halfN/RD5/R2_4 VGND 0.39677f
C381 halfN/RD5/R1_3 VGND 0.39666f
C382 halfN/RD5/R2_2 VGND 0.39677f
C383 halfN/RD5/R1_1 VGND 0.56073f
C384 halfN/xq1/a_35_297# VGND 0.25457f
C385 halfN/xq5/B VGND 0.18682f
C386 uio_out[3] VGND 1.43409f
C387 halfN/dq5/a_381_47# VGND 0.01537f
C388 halfN/dq5/a_891_413# VGND 0.16105f
C389 halfN/dq5/a_1059_315# VGND 0.24885f
C390 halfN/dq5/a_466_413# VGND 0.1332f
C391 halfN/dq5/a_634_159# VGND 0.14231f
C392 halfN/dq5/a_193_47# VGND 0.28426f
C393 halfN/dq5/a_27_47# VGND 0.44951f
C394 halfN/RD4/R1_5 VGND 0.56073f
C395 halfN/RD4/R2_4 VGND 0.39677f
C396 halfN/RD4/R1_3 VGND 0.39666f
C397 halfN/RD4/R2_2 VGND 0.39677f
C398 halfN/RD4/R1_1 VGND 0.56073f
C399 halfN/RD3/R1_5 VGND 0.56073f
C400 halfN/RD3/R2_4 VGND 0.39677f
C401 halfN/RD3/R1_3 VGND 0.39666f
C402 halfN/RD3/R2_2 VGND 0.39677f
C403 halfN/RD3/R1_1 VGND 0.56073f
C404 halfN/xq0/a_35_297# VGND 0.25457f
C405 halfN/xq4/B VGND 0.18682f
C406 uio_out[6] VGND 1.02942f
C407 halfN/dq4/a_381_47# VGND 0.01537f
C408 halfN/dq4/a_891_413# VGND 0.16105f
C409 halfN/dq4/a_1059_315# VGND 0.24885f
C410 halfN/dq4/a_466_413# VGND 0.1332f
C411 halfN/dq4/a_634_159# VGND 0.14231f
C412 halfN/dq4/a_193_47# VGND 0.28426f
C413 halfN/dq4/a_27_47# VGND 0.44951f
C414 halfN/RD2/R1_5 VGND 0.56073f
C415 halfN/RD2/R2_4 VGND 0.39677f
C416 halfN/RD2/R1_3 VGND 0.40562f
C417 halfN/RD2/R2_2 VGND 0.39677f
C418 halfN/xq2/X VGND 1.21177f
C419 halfN/RD2/R1_1 VGND 0.56158f
C420 halfN/xq3/B VGND 0.18682f
C421 uio_out[2] VGND 1.19459f
C422 halfN/dq3/a_381_47# VGND 0.01537f
C423 halfN/dq3/a_891_413# VGND 0.16105f
C424 halfN/dq3/a_1059_315# VGND 0.24885f
C425 halfN/dq3/a_466_413# VGND 0.1332f
C426 halfN/dq3/a_634_159# VGND 0.14231f
C427 halfN/dq3/a_193_47# VGND 0.28426f
C428 halfN/dq3/a_27_47# VGND 0.44951f
C429 halfN/RD1/R1_5 VGND 0.55581f
C430 halfN/RD1/R2_4 VGND 0.39677f
C431 halfN/RD1/R1_3 VGND 0.39236f
C432 halfN/RD1/R2_2 VGND 0.39677f
C433 halfN/xq1/X VGND 1.21835f
C434 halfN/RD1/R1_1 VGND 0.5568f
C435 halfN/xq2/B VGND 0.18682f
C436 halfN/dq2/a_381_47# VGND 0.01537f
C437 halfN/dq2/a_891_413# VGND 0.16105f
C438 halfN/dq2/a_1059_315# VGND 0.24885f
C439 halfN/dq2/a_466_413# VGND 0.1332f
C440 halfN/dq2/a_634_159# VGND 0.14231f
C441 halfN/dq2/a_193_47# VGND 0.28426f
C442 halfN/dq2/a_27_47# VGND 0.44951f
C443 halfN/RD0/R1_5 VGND 0.55546f
C444 halfN/RD0/R2_4 VGND 0.39677f
C445 halfN/RD0/R1_3 VGND 0.39458f
C446 halfN/RD0/R2_2 VGND 0.39677f
C447 halfN/xq0/X VGND 1.29597f
C448 halfN/RD0/R1_1 VGND 0.61415f
C449 halfN/xq1/B VGND 0.18682f
C450 halfN/dq1/a_381_47# VGND 0.01537f
C451 halfN/dq1/a_891_413# VGND 0.16105f
C452 halfN/dq1/a_1059_315# VGND 0.24885f
C453 halfN/dq1/a_466_413# VGND 0.1332f
C454 halfN/dq1/a_634_159# VGND 0.14231f
C455 halfN/dq1/a_193_47# VGND 0.28426f
C456 halfN/dq1/a_27_47# VGND 0.44951f
C457 halfN/xq0/B VGND 0.20094f
C458 halfN/dq0/a_381_47# VGND 0.01537f
C459 halfN/dq0/a_891_413# VGND 0.16105f
C460 halfN/dq0/a_1059_315# VGND 0.24885f
C461 halfN/dq0/a_466_413# VGND 0.1332f
C462 halfN/dq0/a_634_159# VGND 0.14231f
C463 halfN/dq0/a_193_47# VGND 0.28426f
C464 halfN/dq0/a_27_47# VGND 0.44951f
C465 halfN/CM1/C1 VGND 15.59816f
C466 halfN/CM1/C2 VGND 28.13952f
C467 uio_out[0] VGND 0.06158f
C468 halfN/mon/a_27_47# VGND 0.46147f
C469 ua[1] VGND 12.29507f
C470 halfN/RIN/R1_1 VGND 0.82178f
C471 uio_out[4] VGND 1.01315f
C472 halfN/dff6/D VGND 2.47015f
C473 halfN/dff6/a_381_47# VGND 0.0164f
C474 halfN/dff6/a_891_413# VGND 0.16089f
C475 halfN/dff6/a_1062_300# VGND 0.52966f
C476 halfN/dff6/a_475_413# VGND 0.13718f
C477 halfN/dff6/a_634_183# VGND 0.15021f
C478 halfN/dff6/a_193_47# VGND 0.27118f
C479 halfN/dff6/a_27_47# VGND 0.4683f
C480 halfN/dff5/D VGND 4.07731f
C481 halfN/dff5/a_381_47# VGND 0.0164f
C482 halfN/dff5/a_891_413# VGND 0.16089f
C483 halfN/dff5/a_1062_300# VGND 0.52986f
C484 halfN/dff5/a_475_413# VGND 0.13718f
C485 halfN/dff5/a_634_183# VGND 0.15021f
C486 halfN/dff5/a_193_47# VGND 0.27118f
C487 halfN/dff5/a_27_47# VGND 0.4683f
C488 halfN/dff4/D VGND 2.82023f
C489 halfN/dff4/a_381_47# VGND 0.0164f
C490 halfN/dff4/a_891_413# VGND 0.16089f
C491 halfN/dff4/a_1062_300# VGND 0.52966f
C492 halfN/dff4/a_475_413# VGND 0.13718f
C493 halfN/dff4/a_634_183# VGND 0.15021f
C494 halfN/dff4/a_193_47# VGND 0.27119f
C495 halfN/dff4/a_27_47# VGND 0.4683f
C496 halfN/xq6/X VGND 3.84588f
C497 halfN/xq6/a_35_297# VGND 0.25457f
C498 halfN/dff3/D VGND 2.47213f
C499 halfN/dff3/a_381_47# VGND 0.0164f
C500 halfN/dff3/a_891_413# VGND 0.16089f
C501 halfN/dff3/a_1062_300# VGND 0.52966f
C502 halfN/dff3/a_475_413# VGND 0.13718f
C503 halfN/dff3/a_634_183# VGND 0.15021f
C504 halfN/dff3/a_193_47# VGND 0.27118f
C505 halfN/dff3/a_27_47# VGND 0.4683f
C506 halfN/xq5/X VGND 0.57139f
C507 halfN/xq5/a_35_297# VGND 0.25457f
C508 halfN/dff2/D VGND 2.33687f
C509 halfN/dff2/a_381_47# VGND 0.0164f
C510 halfN/dff2/a_891_413# VGND 0.16089f
C511 halfN/dff2/a_1062_300# VGND 0.52966f
C512 halfN/dff2/a_475_413# VGND 0.13718f
C513 halfN/dff2/a_634_183# VGND 0.15021f
C514 halfN/dff2/a_193_47# VGND 0.27123f
C515 halfN/dff2/a_27_47# VGND 0.46832f
C516 halfN/xq4/X VGND 1.38832f
C517 halfN/xq4/a_35_297# VGND 0.25457f
C518 RB/R2_3 VGND 9.833f
C519 RB/R1_3 VGND 0.60464f
C520 RB/R2_2 VGND 0.36641f
C521 RB/R1_1 VGND 0.60517f
C522 RARR/R1_3 VGND 1.0048f
C523 RARR/R2_3 VGND 0.39758f
C524 RARR/R2_4 VGND 0.59222f
C525 RT/R1_7 VGND 0.55583f
C526 RT/R2_6 VGND 0.3693f
C527 RT/R1_5 VGND 0.38618f
C528 RT/R2_4 VGND 0.36952f
C529 RT/R1_3 VGND 0.38618f
C530 RT/R2_2 VGND 0.36939f
C531 RT/R1_1 VGND 0.60823f
.ends
