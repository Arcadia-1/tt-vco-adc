* NGSPICE file created from tt_um_arcadia1_vco_adc.ext - technology: sky130A

.subckt sky130_fd_pr__res_xhigh_po_0p35_4MFQX6 R1_4 R1_3 R1_2 R1_1 R1_0 B R2_7 R2_6
+ R2_5 R2_4 R2_3 R2_2 R2_1 R2_0 R1_7 R1_6 R1_5
X0 R1_0 R2_0 B sky130_fd_pr__res_xhigh_po_0p35 l=4.38
X1 R1_6 R2_6 B sky130_fd_pr__res_xhigh_po_0p35 l=4.38
X2 R1_7 R2_7 B sky130_fd_pr__res_xhigh_po_0p35 l=4.38
X3 R1_5 R2_5 B sky130_fd_pr__res_xhigh_po_0p35 l=4.38
X4 R1_2 R2_2 B sky130_fd_pr__res_xhigh_po_0p35 l=4.38
X5 R1_4 R2_4 B sky130_fd_pr__res_xhigh_po_0p35 l=4.38
X6 R1_1 R2_1 B sky130_fd_pr__res_xhigh_po_0p35 l=4.38
X7 R1_3 R2_3 B sky130_fd_pr__res_xhigh_po_0p35 l=4.38
C0 R1_6 R1_5 0.29626f
C1 R1_1 R1_0 0.29626f
C2 R1_5 R1_4 0.29626f
C3 R2_3 R2_2 0.29626f
C4 R2_2 R2_1 0.29626f
C5 R1_3 R1_2 0.29626f
C6 R2_7 R2_6 0.29626f
C7 R1_2 R1_1 0.29626f
C8 R2_3 R2_4 0.29626f
C9 R1_3 R1_4 0.29626f
C10 R2_0 R2_1 0.29626f
C11 R2_5 R2_4 0.29626f
C12 R1_6 R1_7 0.29626f
C13 R2_5 R2_6 0.29626f
C14 R2_7 B 0.39525f
C15 R1_7 B 0.39525f
C16 R2_6 B 0.17336f
C17 R1_6 B 0.17336f
C18 R2_5 B 0.17325f
C19 R1_5 B 0.17325f
C20 R2_4 B 0.17336f
C21 R1_4 B 0.17336f
C22 R2_3 B 0.17336f
C23 R1_3 B 0.17336f
C24 R2_2 B 0.17325f
C25 R1_2 B 0.17325f
C26 R2_1 B 0.17336f
C27 R1_1 B 0.17336f
C28 R2_0 B 0.39525f
C29 R1_0 B 0.39525f
.ends

.subckt sky130_fd_pr__res_xhigh_po_0p35_9LMN9P R1_4 R1_3 R1_2 R1_1 R1_0 B R2_5 R2_4
+ R2_3 R2_2 R2_1 R2_0 R1_5
X0 R1_0 R2_0 B sky130_fd_pr__res_xhigh_po_0p35 l=20
X1 R1_1 R2_1 B sky130_fd_pr__res_xhigh_po_0p35 l=20
X2 R1_3 R2_3 B sky130_fd_pr__res_xhigh_po_0p35 l=20
X3 R1_4 R2_4 B sky130_fd_pr__res_xhigh_po_0p35 l=20
X4 R1_2 R2_2 B sky130_fd_pr__res_xhigh_po_0p35 l=20
X5 R1_5 R2_5 B sky130_fd_pr__res_xhigh_po_0p35 l=20
C0 R1_2 R1_1 0.29626f
C1 R2_3 R2_2 0.29626f
C2 R1_2 R1_3 0.29626f
C3 R2_1 R2_0 0.29626f
C4 R1_4 R1_3 0.29626f
C5 R2_1 R2_2 0.29626f
C6 R1_5 R1_4 0.29626f
C7 R2_4 R2_5 0.29626f
C8 R2_4 R2_3 0.29626f
C9 R1_0 R1_1 0.29626f
C10 R2_5 B 0.40095f
C11 R1_5 B 0.40095f
C12 R2_4 B 0.17894f
C13 R1_4 B 0.17894f
C14 R2_3 B 0.17883f
C15 R1_3 B 0.17883f
C16 R2_2 B 0.17883f
C17 R1_2 B 0.17883f
C18 R2_1 B 0.17894f
C19 R1_1 B 0.17894f
C20 R2_0 B 0.40095f
C21 R1_0 B 0.40095f
.ends

.subckt sky130_fd_pr__res_xhigh_po_0p35_V6BCNG R1_3 R1_2 R1_1 R1_0 B R2_3 R2_2 R2_1
+ R2_0
X0 R1_1 R2_1 B sky130_fd_pr__res_xhigh_po_0p35 l=3.25
X1 R1_3 R2_3 B sky130_fd_pr__res_xhigh_po_0p35 l=3.25
X2 R1_0 R2_0 B sky130_fd_pr__res_xhigh_po_0p35 l=3.25
X3 R1_2 R2_2 B sky130_fd_pr__res_xhigh_po_0p35 l=3.25
C0 R1_3 R1_2 0.29626f
C1 R2_2 R2_1 0.29626f
C2 R1_1 R1_0 0.29626f
C3 R2_0 R2_1 0.29626f
C4 R1_1 R1_2 0.29626f
C5 R2_3 R2_2 0.29626f
C6 R2_3 B 0.39412f
C7 R1_3 B 0.39412f
C8 R2_2 B 0.17161f
C9 R1_2 B 0.17161f
C10 R2_1 B 0.17161f
C11 R1_1 B 0.17161f
C12 R2_0 B 0.39412f
C13 R1_0 B 0.39412f
.ends

.subckt sky130_fd_sc_hd__xor2_1 VNB VPB VPWR VGND A X B a_285_297# a_35_297#
X0 X a_35_297# a_285_297# VPB sky130_fd_pr__pfet_01v8_hvt ad=0.3 pd=2.6 as=0.26 ps=2.52 w=1 l=0.15
X1 X B a_285_47# VNB sky130_fd_pr__nfet_01v8 ad=0.25025 pd=1.42 as=0.08775 ps=0.92 w=0.65 l=0.15
X2 a_35_297# B VGND VNB sky130_fd_pr__nfet_01v8 ad=0.08775 pd=0.92 as=0.169 ps=1.82 w=0.65 l=0.15
X3 a_117_297# B a_35_297# VPB sky130_fd_pr__pfet_01v8_hvt ad=0.135 pd=1.27 as=0.26 ps=2.52 w=1 l=0.15
X4 VPWR B a_285_297# VPB sky130_fd_pr__pfet_01v8_hvt ad=0.26 pd=2.52 as=0.135 ps=1.27 w=1 l=0.15
X5 VGND A a_35_297# VNB sky130_fd_pr__nfet_01v8 ad=0.08775 pd=0.92 as=0.08775 ps=0.92 w=0.65 l=0.15
X6 VGND a_35_297# X VNB sky130_fd_pr__nfet_01v8 ad=0.208 pd=1.94 as=0.25025 ps=1.42 w=0.65 l=0.15
X7 a_285_297# A VPWR VPB sky130_fd_pr__pfet_01v8_hvt ad=0.135 pd=1.27 as=0.135 ps=1.27 w=1 l=0.15
X8 VPWR A a_117_297# VPB sky130_fd_pr__pfet_01v8_hvt ad=0.135 pd=1.27 as=0.135 ps=1.27 w=1 l=0.15
X9 a_285_47# A VGND VNB sky130_fd_pr__nfet_01v8 ad=0.08775 pd=0.92 as=0.08775 ps=0.92 w=0.65 l=0.15
C0 a_285_297# B 0.05532f
C1 VPB B 0.06969f
C2 a_285_297# VPWR 0.24631f
C3 VPWR VPB 0.06891f
C4 a_285_297# X 0.07125f
C5 X VPB 0.01541f
C6 A VPB 0.05101f
C7 a_35_297# B 0.203f
C8 VPWR a_35_297# 0.09604f
C9 VGND a_35_297# 0.17666f
C10 X a_35_297# 0.166f
C11 a_285_297# VPB 0.01327f
C12 VPWR B 0.07031f
C13 VGND B 0.03045f
C14 X B 0.01488f
C15 VPWR VGND 0.06426f
C16 VPWR X 0.05365f
C17 X VGND 0.1729f
C18 A a_35_297# 0.06334f
C19 A B 0.22134f
C20 A VPWR 0.03484f
C21 A VGND 0.03254f
C22 a_285_297# a_35_297# 0.02504f
C23 VPB a_35_297# 0.06993f
C24 VGND VNB 0.43488f
C25 X VNB 0.06491f
C26 VPWR VNB 0.33278f
C27 A VNB 0.16672f
C28 B VNB 0.21337f
C29 VPB VNB 0.69336f
C30 a_35_297# VNB 0.25457f
.ends

.subckt sky130_fd_sc_hd__dfxtp_4 VGND VPWR VNB VPB Q D CLK a_891_413# a_193_47# a_381_47#
+ a_1062_300# a_475_413# a_634_183# a_27_47#
X0 Q a_1062_300# VPWR VPB sky130_fd_pr__pfet_01v8_hvt ad=0.135 pd=1.27 as=0.1425 ps=1.285 w=1 l=0.15
X1 a_1020_47# a_27_47# a_891_413# VNB sky130_fd_pr__special_nfet_01v8 ad=0.066 pd=0.745 as=0.0657 ps=0.725 w=0.36 l=0.15
X2 a_572_47# a_193_47# a_475_413# VNB sky130_fd_pr__special_nfet_01v8 ad=0.0687 pd=0.76 as=0.0594 ps=0.69 w=0.36 l=0.15
X3 VPWR a_1062_300# a_975_413# VPB sky130_fd_pr__pfet_01v8_hvt ad=0.1218 pd=1.42 as=0.09135 ps=0.855 w=0.42 l=0.15
X4 a_634_183# a_475_413# VGND VNB sky130_fd_pr__nfet_01v8 ad=0.0989 pd=0.995 as=0.1493 ps=1.22 w=0.64 l=0.15
X5 VPWR CLK a_27_47# VPB sky130_fd_pr__pfet_01v8_hvt ad=0.0864 pd=0.91 as=0.1664 ps=1.8 w=0.64 l=0.15
X6 a_381_47# D VPWR VPB sky130_fd_pr__pfet_01v8_hvt ad=0.0672 pd=0.74 as=0.1092 ps=1.36 w=0.42 l=0.15
X7 a_475_413# a_27_47# a_381_47# VNB sky130_fd_pr__special_nfet_01v8 ad=0.0594 pd=0.69 as=0.066 ps=0.745 w=0.36 l=0.15
X8 VGND a_1062_300# a_1020_47# VNB sky130_fd_pr__nfet_01v8 ad=0.1197 pd=1.41 as=0.066 ps=0.745 w=0.42 l=0.15
X9 VPWR a_634_183# a_568_413# VPB sky130_fd_pr__pfet_01v8_hvt ad=0.17887 pd=1.26 as=0.0693 ps=0.75 w=0.42 l=0.15
X10 Q a_1062_300# VGND VNB sky130_fd_pr__nfet_01v8 ad=0.08775 pd=0.92 as=0.09262 ps=0.935 w=0.65 l=0.15
X11 a_568_413# a_27_47# a_475_413# VPB sky130_fd_pr__pfet_01v8_hvt ad=0.0693 pd=0.75 as=0.06615 ps=0.735 w=0.42 l=0.15
X12 a_634_183# a_475_413# VPWR VPB sky130_fd_pr__pfet_01v8_hvt ad=0.1095 pd=1.075 as=0.17887 ps=1.26 w=0.75 l=0.15
X13 a_975_413# a_193_47# a_891_413# VPB sky130_fd_pr__pfet_01v8_hvt ad=0.09135 pd=0.855 as=0.0567 ps=0.69 w=0.42 l=0.15
X14 a_193_47# a_27_47# VGND VNB sky130_fd_pr__nfet_01v8 ad=0.1092 pd=1.36 as=0.0567 ps=0.69 w=0.42 l=0.15
X15 a_891_413# a_27_47# a_634_183# VPB sky130_fd_pr__pfet_01v8_hvt ad=0.0567 pd=0.69 as=0.1095 ps=1.075 w=0.42 l=0.15
X16 Q a_1062_300# VGND VNB sky130_fd_pr__nfet_01v8 ad=0.08775 pd=0.92 as=0.10563 ps=0.975 w=0.65 l=0.15
X17 VGND a_891_413# a_1062_300# VNB sky130_fd_pr__nfet_01v8 ad=0.10563 pd=0.975 as=0.169 ps=1.82 w=0.65 l=0.15
X18 VPWR a_1062_300# Q VPB sky130_fd_pr__pfet_01v8_hvt ad=0.1425 pd=1.285 as=0.135 ps=1.27 w=1 l=0.15
X19 VGND a_1062_300# Q VNB sky130_fd_pr__nfet_01v8 ad=0.18525 pd=1.87 as=0.08775 ps=0.92 w=0.65 l=0.15
X20 Q a_1062_300# VPWR VPB sky130_fd_pr__pfet_01v8_hvt ad=0.135 pd=1.27 as=0.1625 ps=1.325 w=1 l=0.15
X21 a_193_47# a_27_47# VPWR VPB sky130_fd_pr__pfet_01v8_hvt ad=0.1664 pd=1.8 as=0.0864 ps=0.91 w=0.64 l=0.15
X22 VGND a_1062_300# Q VNB sky130_fd_pr__nfet_01v8 ad=0.09262 pd=0.935 as=0.08775 ps=0.92 w=0.65 l=0.15
X23 a_381_47# D VGND VNB sky130_fd_pr__nfet_01v8 ad=0.066 pd=0.745 as=0.1092 ps=1.36 w=0.42 l=0.15
X24 VPWR a_891_413# a_1062_300# VPB sky130_fd_pr__pfet_01v8_hvt ad=0.1625 pd=1.325 as=0.28 ps=2.56 w=1 l=0.15
X25 a_475_413# a_193_47# a_381_47# VPB sky130_fd_pr__pfet_01v8_hvt ad=0.06615 pd=0.735 as=0.0672 ps=0.74 w=0.42 l=0.15
X26 a_891_413# a_193_47# a_634_183# VNB sky130_fd_pr__special_nfet_01v8 ad=0.0657 pd=0.725 as=0.0989 ps=0.995 w=0.36 l=0.15
X27 VGND a_634_183# a_572_47# VNB sky130_fd_pr__nfet_01v8 ad=0.1493 pd=1.22 as=0.0687 ps=0.76 w=0.42 l=0.15
X28 VGND CLK a_27_47# VNB sky130_fd_pr__nfet_01v8 ad=0.0567 pd=0.69 as=0.1092 ps=1.36 w=0.42 l=0.15
X29 VPWR a_1062_300# Q VPB sky130_fd_pr__pfet_01v8_hvt ad=0.28 pd=2.56 as=0.135 ps=1.27 w=1 l=0.15
C0 VGND a_381_47# 0.04483f
C1 a_891_413# a_27_47# 0.03777f
C2 a_891_413# a_634_183# 0.03548f
C3 a_891_413# a_193_47# 0.13928f
C4 a_891_413# VPB 0.06876f
C5 a_1062_300# a_891_413# 0.28549f
C6 Q VGND 0.24206f
C7 D VGND 0.0264f
C8 a_27_47# a_381_47# 0.03397f
C9 VPWR VGND 0.10063f
C10 a_193_47# a_381_47# 0.16187f
C11 VPB a_381_47# 0.01358f
C12 VPWR CLK 0.01941f
C13 VPB Q 0.01336f
C14 a_1062_300# Q 0.38792f
C15 D a_27_47# 0.09699f
C16 a_475_413# a_381_47# 0.03564f
C17 VPWR a_27_47# 0.3831f
C18 D a_193_47# 0.10396f
C19 D VPB 0.09609f
C20 VPWR a_634_183# 0.10209f
C21 VPWR a_193_47# 0.10663f
C22 VPWR VPB 0.19856f
C23 a_1062_300# VPWR 0.22605f
C24 VPWR a_475_413# 0.16822f
C25 CLK VGND 0.01946f
C26 a_27_47# VGND 0.12468f
C27 a_634_183# VGND 0.12391f
C28 a_193_47# VGND 0.30543f
C29 VPB VGND 0.01466f
C30 a_1062_300# VGND 0.19483f
C31 a_27_47# CLK 0.21376f
C32 a_475_413# VGND 0.09216f
C33 VPB CLK 0.07006f
C34 a_27_47# a_634_183# 0.16612f
C35 a_891_413# VPWR 0.11394f
C36 a_27_47# a_193_47# 0.72386f
C37 a_27_47# VPB 0.27543f
C38 a_1062_300# a_27_47# 0.04869f
C39 a_193_47# a_634_183# 0.13099f
C40 VPB a_634_183# 0.07362f
C41 VPB a_193_47# 0.14138f
C42 a_1062_300# a_193_47# 0.03024f
C43 a_1062_300# VPB 0.24732f
C44 a_27_47# a_475_413# 0.17844f
C45 D a_381_47# 0.07679f
C46 a_475_413# a_634_183# 0.24864f
C47 VPWR a_381_47# 0.05338f
C48 a_193_47# a_475_413# 0.15754f
C49 VPB a_475_413# 0.07594f
C50 a_891_413# VGND 0.11673f
C51 VPWR Q 0.33578f
C52 D VPWR 0.02726f
C53 Q VNB 0.0608f
C54 VGND VNB 0.98893f
C55 VPWR VNB 0.82311f
C56 D VNB 0.12973f
C57 CLK VNB 0.19598f
C58 VPB VNB 1.75651f
C59 a_381_47# VNB 0.0164f
C60 a_891_413# VNB 0.16089f
C61 a_1062_300# VNB 0.52966f
C62 a_475_413# VNB 0.13718f
C63 a_634_183# VNB 0.15021f
C64 a_193_47# VNB 0.27118f
C65 a_27_47# VNB 0.4683f
.ends

.subckt sky130_fd_pr__res_xhigh_po_0p35_Z9GLRM R1_4 R1_18 R1_29 R1_3 R1_17 R1_28 R1_39
+ R1_2 R1_16 R1_27 R1_38 R1_1 R1_15 R1_26 R1_37 R1_14 R1_25 R1_36 R1_13 R1_24 R1_35
+ B R1_12 R1_23 R1_34 R1_22 R1_33 R1_11 R1_21 R1_32 R1_10 R1_20 R1_31 R1_42 R1_30
+ R1_41 R1_40 R2_9 R2_8 R2_7 R2_6 R2_5 R2_4 R2_3 R2_2 R2_1 R2_19 R2_0 R2_18 R2_29
+ R2_17 R2_28 R2_39 R2_16 R2_27 R2_38 R2_15 R2_26 R2_37 R2_14 R2_25 R2_36 R2_13 R2_24
+ R2_35 R2_12 R2_23 R2_34 R1_9 R2_22 R2_33 R2_11 R1_8 R2_21 R2_32 R2_43 R2_10 R1_7
+ R2_20 R2_31 R2_42 R1_6 R2_30 R2_41 R1_5 R2_40 R1_19
X0 R1_38 R2_38 B sky130_fd_pr__res_xhigh_po_0p35 l=30.3
X1 R1_41 R2_41 B sky130_fd_pr__res_xhigh_po_0p35 l=30.3
X2 R1_16 R2_16 B sky130_fd_pr__res_xhigh_po_0p35 l=30.3
X3 R1_17 R2_17 B sky130_fd_pr__res_xhigh_po_0p35 l=30.3
X4 R1_30 R2_30 B sky130_fd_pr__res_xhigh_po_0p35 l=30.3
X5 R1_27 R2_27 B sky130_fd_pr__res_xhigh_po_0p35 l=30.3
X6 R1_13 R2_13 B sky130_fd_pr__res_xhigh_po_0p35 l=30.3
X7 R1_9 R2_9 B sky130_fd_pr__res_xhigh_po_0p35 l=30.3
X8 R1_33 R2_33 B sky130_fd_pr__res_xhigh_po_0p35 l=30.3
X9 R1_37 R2_37 B sky130_fd_pr__res_xhigh_po_0p35 l=30.3
X10 R1_36 R2_36 B sky130_fd_pr__res_xhigh_po_0p35 l=30.3
X11 R1_40 R2_40 B sky130_fd_pr__res_xhigh_po_0p35 l=30.3
X12 R1_6 R2_6 B sky130_fd_pr__res_xhigh_po_0p35 l=30.3
X13 R1_10 R2_10 B sky130_fd_pr__res_xhigh_po_0p35 l=30.3
X14 R1_23 R2_23 B sky130_fd_pr__res_xhigh_po_0p35 l=30.3
X15 R1_3 R2_3 B sky130_fd_pr__res_xhigh_po_0p35 l=30.3
X16 R1_7 R2_7 B sky130_fd_pr__res_xhigh_po_0p35 l=30.3
X17 R1_39 R2_39 B sky130_fd_pr__res_xhigh_po_0p35 l=30.3
X18 R1_14 R2_14 B sky130_fd_pr__res_xhigh_po_0p35 l=30.3
X19 R1_29 R2_29 B sky130_fd_pr__res_xhigh_po_0p35 l=30.3
X20 R1_43 R2_43 B sky130_fd_pr__res_xhigh_po_0p35 l=30.3
X21 R1_26 R2_26 B sky130_fd_pr__res_xhigh_po_0p35 l=30.3
X22 R1_0 R2_0 B sky130_fd_pr__res_xhigh_po_0p35 l=30.3
X23 R1_21 R2_21 B sky130_fd_pr__res_xhigh_po_0p35 l=30.3
X24 R1_11 R2_11 B sky130_fd_pr__res_xhigh_po_0p35 l=30.3
X25 R1_8 R2_8 B sky130_fd_pr__res_xhigh_po_0p35 l=30.3
X26 R1_18 R2_18 B sky130_fd_pr__res_xhigh_po_0p35 l=30.3
X27 R1_28 R2_28 B sky130_fd_pr__res_xhigh_po_0p35 l=30.3
X28 R1_42 R2_42 B sky130_fd_pr__res_xhigh_po_0p35 l=30.3
X29 R1_4 R2_4 B sky130_fd_pr__res_xhigh_po_0p35 l=30.3
X30 R1_5 R2_5 B sky130_fd_pr__res_xhigh_po_0p35 l=30.3
X31 R1_24 R2_24 B sky130_fd_pr__res_xhigh_po_0p35 l=30.3
X32 R1_25 R2_25 B sky130_fd_pr__res_xhigh_po_0p35 l=30.3
X33 R1_1 R2_1 B sky130_fd_pr__res_xhigh_po_0p35 l=30.3
X34 R1_2 R2_2 B sky130_fd_pr__res_xhigh_po_0p35 l=30.3
X35 R1_15 R2_15 B sky130_fd_pr__res_xhigh_po_0p35 l=30.3
X36 R1_31 R2_31 B sky130_fd_pr__res_xhigh_po_0p35 l=30.3
X37 R1_32 R2_32 B sky130_fd_pr__res_xhigh_po_0p35 l=30.3
X38 R1_34 R2_34 B sky130_fd_pr__res_xhigh_po_0p35 l=30.3
X39 R1_35 R2_35 B sky130_fd_pr__res_xhigh_po_0p35 l=30.3
X40 R1_12 R2_12 B sky130_fd_pr__res_xhigh_po_0p35 l=30.3
X41 R1_19 R2_19 B sky130_fd_pr__res_xhigh_po_0p35 l=30.3
X42 R1_20 R2_20 B sky130_fd_pr__res_xhigh_po_0p35 l=30.3
X43 R1_22 R2_22 B sky130_fd_pr__res_xhigh_po_0p35 l=30.3
C0 R2_16 R2_15 0.29626f
C1 R2_23 R2_22 0.29626f
C2 R1_40 R1_39 0.29626f
C3 R1_31 R1_30 0.29626f
C4 R1_16 R1_17 0.29626f
C5 R2_28 R2_27 0.29626f
C6 R2_6 R2_7 0.29626f
C7 R1_35 R1_34 0.29626f
C8 R1_5 R1_4 0.29626f
C9 R1_15 R1_14 0.29626f
C10 R1_10 R1_11 0.29626f
C11 R2_7 R2_8 0.29626f
C12 R2_34 R2_33 0.29626f
C13 R2_17 R2_18 0.29626f
C14 R1_38 R1_37 0.29626f
C15 R2_40 R2_41 0.29626f
C16 R2_36 R2_37 0.29626f
C17 R2_19 R2_18 0.29626f
C18 R2_17 R2_16 0.29626f
C19 R2_31 R2_30 0.29626f
C20 R2_12 R2_13 0.29626f
C21 R1_10 R1_9 0.29626f
C22 R1_6 R1_5 0.29626f
C23 R1_36 R1_37 0.29626f
C24 R2_10 R2_9 0.29626f
C25 R1_32 R1_31 0.29626f
C26 R1_28 R1_27 0.29626f
C27 R2_24 R2_23 0.29626f
C28 R1_12 R1_11 0.29626f
C29 R1_23 R1_24 0.29626f
C30 R2_42 R2_41 0.29626f
C31 R1_15 R1_16 0.29626f
C32 R1_25 R1_24 0.29626f
C33 R2_3 R2_4 0.29626f
C34 R1_2 R1_3 0.29626f
C35 R1_18 R1_19 0.29626f
C36 R1_17 R1_18 0.29626f
C37 R1_13 R1_14 0.29626f
C38 R1_0 R1_1 0.29626f
C39 R2_1 R2_2 0.29626f
C40 R2_24 R2_25 0.29626f
C41 R1_9 R1_8 0.29626f
C42 R1_42 R1_41 0.29626f
C43 R2_32 R2_31 0.29626f
C44 R2_6 R2_5 0.29626f
C45 R2_34 R2_35 0.29626f
C46 R1_22 R1_21 0.29626f
C47 R2_9 R2_8 0.29626f
C48 R2_10 R2_11 0.29626f
C49 R1_12 R1_13 0.29626f
C50 R1_33 R1_32 0.29626f
C51 R1_20 R1_21 0.29626f
C52 R1_29 R1_28 0.29626f
C53 R2_22 R2_21 0.29626f
C54 R2_25 R2_26 0.29626f
C55 R1_4 R1_3 0.29626f
C56 R2_14 R2_15 0.29626f
C57 R2_38 R2_37 0.29626f
C58 R2_3 R2_2 0.29626f
C59 R1_8 R1_7 0.29626f
C60 R1_6 R1_7 0.29626f
C61 R2_29 R2_28 0.29626f
C62 R2_36 R2_35 0.29626f
C63 R1_20 R1_19 0.29626f
C64 R1_26 R1_27 0.29626f
C65 R2_1 R2_0 0.29626f
C66 R2_33 R2_32 0.29626f
C67 R1_2 R1_1 0.29626f
C68 R2_4 R2_5 0.29626f
C69 R2_27 R2_26 0.29626f
C70 R1_38 R1_39 0.29626f
C71 R1_30 R1_29 0.29626f
C72 R2_38 R2_39 0.29626f
C73 R1_40 R1_41 0.29626f
C74 R1_36 R1_35 0.29626f
C75 R1_34 R1_33 0.29626f
C76 R2_42 R2_43 0.29626f
C77 R2_14 R2_13 0.29626f
C78 R2_19 R2_20 0.29626f
C79 R1_23 R1_22 0.29626f
C80 R2_40 R2_39 0.29626f
C81 R1_42 R1_43 0.29626f
C82 R2_12 R2_11 0.29626f
C83 R2_30 R2_29 0.29626f
C84 R2_20 R2_21 0.29626f
C85 R1_25 R1_26 0.29626f
C86 R2_43 B 0.40066f
C87 R1_43 B 0.40066f
C88 R2_42 B 0.17894f
C89 R1_42 B 0.17894f
C90 R2_41 B 0.17883f
C91 R1_41 B 0.17883f
C92 R2_40 B 0.17894f
C93 R1_40 B 0.17894f
C94 R2_39 B 0.17883f
C95 R1_39 B 0.17883f
C96 R2_38 B 0.17883f
C97 R1_38 B 0.17883f
C98 R2_37 B 0.17894f
C99 R1_37 B 0.17894f
C100 R2_36 B 0.17883f
C101 R1_36 B 0.17883f
C102 R2_35 B 0.17894f
C103 R1_35 B 0.17894f
C104 R2_34 B 0.17883f
C105 R1_34 B 0.17883f
C106 R2_33 B 0.17894f
C107 R1_33 B 0.17894f
C108 R2_32 B 0.17883f
C109 R1_32 B 0.17883f
C110 R2_31 B 0.17894f
C111 R1_31 B 0.17894f
C112 R2_30 B 0.17889f
C113 R1_30 B 0.17889f
C114 R2_29 B 0.17883f
C115 R1_29 B 0.17883f
C116 R2_28 B 0.17894f
C117 R1_28 B 0.17894f
C118 R2_27 B 0.17883f
C119 R1_27 B 0.17883f
C120 R2_26 B 0.17894f
C121 R1_26 B 0.17894f
C122 R2_25 B 0.17883f
C123 R1_25 B 0.17883f
C124 R2_24 B 0.17894f
C125 R1_24 B 0.17894f
C126 R2_23 B 0.17883f
C127 R1_23 B 0.17883f
C128 R2_22 B 0.17894f
C129 R1_22 B 0.17894f
C130 R2_21 B 0.17894f
C131 R1_21 B 0.17894f
C132 R2_20 B 0.17883f
C133 R1_20 B 0.17883f
C134 R2_19 B 0.17894f
C135 R1_19 B 0.17894f
C136 R2_18 B 0.17883f
C137 R1_18 B 0.17883f
C138 R2_17 B 0.17894f
C139 R1_17 B 0.17894f
C140 R2_16 B 0.17883f
C141 R1_16 B 0.17883f
C142 R2_15 B 0.17894f
C143 R1_15 B 0.17894f
C144 R2_14 B 0.17883f
C145 R1_14 B 0.17883f
C146 R2_13 B 0.17889f
C147 R1_13 B 0.17889f
C148 R2_12 B 0.17894f
C149 R1_12 B 0.17894f
C150 R2_11 B 0.17883f
C151 R1_11 B 0.17883f
C152 R2_10 B 0.17894f
C153 R1_10 B 0.17894f
C154 R2_9 B 0.17883f
C155 R1_9 B 0.17883f
C156 R2_8 B 0.17894f
C157 R1_8 B 0.17894f
C158 R2_7 B 0.17883f
C159 R1_7 B 0.17883f
C160 R2_6 B 0.17894f
C161 R1_6 B 0.17894f
C162 R2_5 B 0.17883f
C163 R1_5 B 0.17883f
C164 R2_4 B 0.17883f
C165 R1_4 B 0.17883f
C166 R2_3 B 0.17894f
C167 R1_3 B 0.17894f
C168 R2_2 B 0.17883f
C169 R1_2 B 0.17883f
C170 R2_1 B 0.17894f
C171 R1_1 B 0.17894f
C172 R2_0 B 0.40066f
C173 R1_0 B 0.40066f
.ends

.subckt sky130_fd_pr__res_xhigh_po_0p35_Y3K97R R1_1 R1_0 B R2_1 R2_0
X0 R1_1 R2_1 B sky130_fd_pr__res_xhigh_po_0p35 l=4.3
X1 R1_0 R2_0 B sky130_fd_pr__res_xhigh_po_0p35 l=4.3
C0 R2_0 R2_1 0.29626f
C1 R1_0 R1_1 0.29626f
C2 R2_1 B 0.39561f
C3 R1_1 B 0.39561f
C4 R2_0 B 0.39561f
C5 R1_0 B 0.39561f
.ends

.subckt sky130_fd_sc_hd__buf_4 VPWR VGND X A VPB VNB a_27_47#
X0 VPWR a_27_47# X VPB sky130_fd_pr__pfet_01v8_hvt ad=0.26 pd=2.52 as=0.135 ps=1.27 w=1 l=0.15
X1 X a_27_47# VPWR VPB sky130_fd_pr__pfet_01v8_hvt ad=0.135 pd=1.27 as=0.135 ps=1.27 w=1 l=0.15
X2 VPWR a_27_47# X VPB sky130_fd_pr__pfet_01v8_hvt ad=0.135 pd=1.27 as=0.135 ps=1.27 w=1 l=0.15
X3 X a_27_47# VPWR VPB sky130_fd_pr__pfet_01v8_hvt ad=0.135 pd=1.27 as=0.135 ps=1.27 w=1 l=0.15
X4 X a_27_47# VGND VNB sky130_fd_pr__nfet_01v8 ad=0.08775 pd=0.92 as=0.08775 ps=0.92 w=0.65 l=0.15
X5 X a_27_47# VGND VNB sky130_fd_pr__nfet_01v8 ad=0.08775 pd=0.92 as=0.08775 ps=0.92 w=0.65 l=0.15
X6 VGND a_27_47# X VNB sky130_fd_pr__nfet_01v8 ad=0.08775 pd=0.92 as=0.08775 ps=0.92 w=0.65 l=0.15
X7 VGND a_27_47# X VNB sky130_fd_pr__nfet_01v8 ad=0.169 pd=1.82 as=0.08775 ps=0.92 w=0.65 l=0.15
X8 VPWR A a_27_47# VPB sky130_fd_pr__pfet_01v8_hvt ad=0.135 pd=1.27 as=0.26 ps=2.52 w=1 l=0.15
X9 VGND A a_27_47# VNB sky130_fd_pr__nfet_01v8 ad=0.08775 pd=0.92 as=0.169 ps=1.82 w=0.65 l=0.15
C0 VGND VPWR 0.07203f
C1 X a_27_47# 0.20651f
C2 A a_27_47# 0.17018f
C3 X VPWR 0.33254f
C4 VPB a_27_47# 0.13215f
C5 A VPB 0.03609f
C6 X VGND 0.22989f
C7 VPWR a_27_47# 0.21812f
C8 A VPWR 0.01601f
C9 VPWR VPB 0.07107f
C10 VGND a_27_47# 0.16264f
C11 A VGND 0.01937f
C12 VGND VNB 0.37777f
C13 X VNB 0.03903f
C14 VPWR VNB 0.32508f
C15 A VNB 0.13997f
C16 VPB VNB 0.60476f
C17 a_27_47# VNB 0.46146f
.ends

.subckt sky130_fd_pr__cap_mim_m3_1_4SMZ5E C1 C2 VSUBS
X0 C1 C2 sky130_fd_pr__cap_mim_m3_1 l=25 w=24
C0 C2 C1 53.1086f
C1 C1 VSUBS 2.52332f
C2 C2 VSUBS 13.4166f
.ends

.subckt sky130_fd_sc_hd__dfxtp_1 Q CLK D VPB VNB VPWR VGND a_891_413# a_466_413# a_1059_315#
+ a_193_47# a_634_159# a_381_47# a_27_47#
X0 Q a_1059_315# VGND VNB sky130_fd_pr__nfet_01v8 ad=0.169 pd=1.82 as=0.08775 ps=0.92 w=0.65 l=0.15
X1 a_891_413# a_193_47# a_634_159# VNB sky130_fd_pr__special_nfet_01v8 ad=0.0684 pd=0.74 as=0.0989 ps=0.995 w=0.36 l=0.15
X2 a_561_413# a_27_47# a_466_413# VPB sky130_fd_pr__pfet_01v8_hvt ad=0.07665 pd=0.785 as=0.06825 ps=0.745 w=0.42 l=0.15
X3 VPWR CLK a_27_47# VPB sky130_fd_pr__pfet_01v8_hvt ad=0.0864 pd=0.91 as=0.1664 ps=1.8 w=0.64 l=0.15
X4 Q a_1059_315# VPWR VPB sky130_fd_pr__pfet_01v8_hvt ad=0.26 pd=2.52 as=0.135 ps=1.27 w=1 l=0.15
X5 a_381_47# D VPWR VPB sky130_fd_pr__pfet_01v8_hvt ad=0.05775 pd=0.695 as=0.1092 ps=1.36 w=0.42 l=0.15
X6 VGND a_634_159# a_592_47# VNB sky130_fd_pr__nfet_01v8 ad=0.12095 pd=1.085 as=0.0696 ps=0.765 w=0.42 l=0.15
X7 VPWR a_891_413# a_1059_315# VPB sky130_fd_pr__pfet_01v8_hvt ad=0.135 pd=1.27 as=0.27 ps=2.54 w=1 l=0.15
X8 a_466_413# a_193_47# a_381_47# VPB sky130_fd_pr__pfet_01v8_hvt ad=0.06825 pd=0.745 as=0.05775 ps=0.695 w=0.42 l=0.15
X9 VPWR a_634_159# a_561_413# VPB sky130_fd_pr__pfet_01v8_hvt ad=0.17887 pd=1.26 as=0.07665 ps=0.785 w=0.42 l=0.15
X10 a_634_159# a_466_413# VGND VNB sky130_fd_pr__nfet_01v8 ad=0.0989 pd=0.995 as=0.12095 ps=1.085 w=0.64 l=0.15
X11 a_634_159# a_466_413# VPWR VPB sky130_fd_pr__pfet_01v8_hvt ad=0.1095 pd=1.075 as=0.17887 ps=1.26 w=0.75 l=0.15
X12 a_975_413# a_193_47# a_891_413# VPB sky130_fd_pr__pfet_01v8_hvt ad=0.0882 pd=0.84 as=0.0567 ps=0.69 w=0.42 l=0.15
X13 VGND a_1059_315# a_1017_47# VNB sky130_fd_pr__nfet_01v8 ad=0.1092 pd=1.36 as=0.066 ps=0.745 w=0.42 l=0.15
X14 a_193_47# a_27_47# VGND VNB sky130_fd_pr__nfet_01v8 ad=0.1092 pd=1.36 as=0.0567 ps=0.69 w=0.42 l=0.15
X15 a_891_413# a_27_47# a_634_159# VPB sky130_fd_pr__pfet_01v8_hvt ad=0.0567 pd=0.69 as=0.1095 ps=1.075 w=0.42 l=0.15
X16 a_592_47# a_193_47# a_466_413# VNB sky130_fd_pr__special_nfet_01v8 ad=0.0696 pd=0.765 as=0.0621 ps=0.705 w=0.36 l=0.15
X17 VPWR a_1059_315# a_975_413# VPB sky130_fd_pr__pfet_01v8_hvt ad=0.1113 pd=1.37 as=0.0882 ps=0.84 w=0.42 l=0.15
X18 a_1017_47# a_27_47# a_891_413# VNB sky130_fd_pr__special_nfet_01v8 ad=0.066 pd=0.745 as=0.0684 ps=0.74 w=0.36 l=0.15
X19 a_193_47# a_27_47# VPWR VPB sky130_fd_pr__pfet_01v8_hvt ad=0.1664 pd=1.8 as=0.0864 ps=0.91 w=0.64 l=0.15
X20 a_466_413# a_27_47# a_381_47# VNB sky130_fd_pr__special_nfet_01v8 ad=0.0621 pd=0.705 as=0.0813 ps=0.83 w=0.36 l=0.15
X21 VGND a_891_413# a_1059_315# VNB sky130_fd_pr__nfet_01v8 ad=0.08775 pd=0.92 as=0.169 ps=1.82 w=0.65 l=0.15
X22 a_381_47# D VGND VNB sky130_fd_pr__nfet_01v8 ad=0.0813 pd=0.83 as=0.1092 ps=1.36 w=0.42 l=0.15
X23 VGND CLK a_27_47# VNB sky130_fd_pr__nfet_01v8 ad=0.0567 pd=0.69 as=0.1092 ps=1.36 w=0.42 l=0.15
C0 a_1059_315# VPB 0.15474f
C1 a_193_47# VPB 0.17613f
C2 VPWR a_27_47# 0.37986f
C3 a_381_47# VGND 0.05222f
C4 a_193_47# a_381_47# 0.10164f
C5 a_891_413# a_27_47# 0.03224f
C6 a_466_413# VPWR 0.17098f
C7 a_381_47# VPB 0.01414f
C8 a_27_47# D 0.06586f
C9 CLK a_27_47# 0.21384f
C10 VPWR a_634_159# 0.10213f
C11 a_891_413# a_634_159# 0.03684f
C12 VPWR Q 0.11093f
C13 VPWR VGND 0.06389f
C14 VPWR a_1059_315# 0.23245f
C15 a_466_413# a_27_47# 0.27314f
C16 a_193_47# VPWR 0.11722f
C17 a_891_413# VGND 0.13154f
C18 a_891_413# a_1059_315# 0.31086f
C19 VPWR VPB 0.16818f
C20 a_891_413# a_193_47# 0.19685f
C21 D VGND 0.03899f
C22 a_634_159# a_27_47# 0.14145f
C23 CLK VGND 0.01946f
C24 a_193_47# D 0.17578f
C25 a_891_413# VPB 0.06977f
C26 VPWR a_381_47# 0.06128f
C27 a_466_413# a_634_159# 0.23992f
C28 D VPB 0.09633f
C29 CLK VPB 0.07006f
C30 a_27_47# VGND 0.13669f
C31 a_381_47# D 0.11219f
C32 a_1059_315# a_27_47# 0.04875f
C33 a_193_47# a_27_47# 0.97453f
C34 a_466_413# VGND 0.0888f
C35 a_27_47# VPB 0.24782f
C36 a_466_413# a_193_47# 0.08301f
C37 a_466_413# VPB 0.07446f
C38 a_634_159# VGND 0.12488f
C39 a_381_47# a_27_47# 0.06222f
C40 a_193_47# a_634_159# 0.12729f
C41 a_466_413# a_381_47# 0.03733f
C42 a_634_159# VPB 0.07647f
C43 a_891_413# VPWR 0.11532f
C44 Q VGND 0.07661f
C45 VPWR D 0.02507f
C46 Q a_1059_315# 0.08125f
C47 a_1059_315# VGND 0.15512f
C48 CLK VPWR 0.01941f
C49 a_193_47# VGND 0.2001f
C50 a_193_47# a_1059_315# 0.03405f
C51 Q VPB 0.01383f
C52 VPB VGND 0.01223f
C53 Q VNB 0.08826f
C54 VGND VNB 0.84362f
C55 VPWR VNB 0.68137f
C56 D VNB 0.14251f
C57 CLK VNB 0.19598f
C58 VPB VNB 1.49072f
C59 a_381_47# VNB 0.01537f
C60 a_891_413# VNB 0.16105f
C61 a_1059_315# VNB 0.24885f
C62 a_466_413# VNB 0.1332f
C63 a_634_159# VNB 0.14231f
C64 a_193_47# VNB 0.28426f
C65 a_27_47# VNB 0.44951f
.ends

.subckt vco_adc_half a_4654_26861# mon/A xq3/X CM1/C1 a_520_37976# a_1906_26237# w_440_39556#
+ a_586_39570# xq1/A a_3032_26237# xq6/A a_1800_26100# mon/X xq6/VPB xq4/X xq1/VPB
+ dq6/CLK RDA/R1_18 xq5/VPB xq6/X CM1/C2 dff6/CLK dff5/D xq3/A xq4/A xq0/A xq5/A w_2846_27270#
+ RDA/R1_22 xq5/X RIN/R2_0 dff4/D xq2/A RIN/B xq3/VPB
Xxq4 RIN/B xq5/VPB xq5/VPB RIN/B xq4/A xq4/X xq4/B xq4/a_285_297# xq4/a_35_297# sky130_fd_sc_hd__xor2_1
Xdff2 RIN/B xq1/VPB RIN/B xq1/VPB xq3/A dff2/D dff6/CLK dff2/a_891_413# dff2/a_193_47#
+ dff2/a_381_47# dff2/a_1062_300# dff2/a_475_413# dff2/a_634_183# dff2/a_27_47# sky130_fd_sc_hd__dfxtp_4
Xxq5 RIN/B xq5/VPB xq5/VPB RIN/B xq5/A xq5/X xq5/B xq5/a_285_297# xq5/a_35_297# sky130_fd_sc_hd__xor2_1
Xdff3 RIN/B xq1/VPB RIN/B xq1/VPB xq4/A dff3/D dff6/CLK dff3/a_891_413# dff3/a_193_47#
+ dff3/a_381_47# dff3/a_1062_300# dff3/a_475_413# dff3/a_634_183# dff3/a_27_47# sky130_fd_sc_hd__dfxtp_4
Xxq6 RIN/B xq6/VPB xq6/VPB RIN/B xq6/A xq6/X xq6/B xq6/a_285_297# xq6/a_35_297# sky130_fd_sc_hd__xor2_1
Xdff4 RIN/B xq1/VPB RIN/B xq1/VPB xq5/A dff4/D dff6/CLK dff4/a_891_413# dff4/a_193_47#
+ dff4/a_381_47# dff4/a_1062_300# dff4/a_475_413# dff4/a_634_183# dff4/a_27_47# sky130_fd_sc_hd__dfxtp_4
Xdff5 RIN/B xq1/VPB RIN/B xq1/VPB xq6/A dff5/D dff6/CLK dff5/a_891_413# dff5/a_193_47#
+ dff5/a_381_47# dff5/a_1062_300# dff5/a_475_413# dff5/a_634_183# dff5/a_27_47# sky130_fd_sc_hd__dfxtp_4
Xdff6 RIN/B xq3/VPB RIN/B xq3/VPB xq2/A dff6/D dff6/CLK dff6/a_891_413# dff6/a_193_47#
+ dff6/a_381_47# dff6/a_1062_300# dff6/a_475_413# dff6/a_634_183# dff6/a_27_47# sky130_fd_sc_hd__dfxtp_4
XRDA RDA/R1_4 RDA/R1_18 RDA/R1_30 RDA/R1_4 RDA/R1_18 RDA/R1_28 RDA/R1_40 RDA/R1_2
+ RDA/R1_16 RDA/R1_28 RDA/R1_38 RDA/R1_2 RDA/R1_16 RDA/R1_26 RDA/R1_38 RDA/R1_14 RDA/R1_26
+ RDA/R1_36 RDA/R1_14 RDA/R1_24 RDA/R1_36 RIN/B RDA/R1_12 RDA/R1_24 RDA/R1_34 RDA/R1_22
+ RDA/R1_34 RDA/R1_12 RDA/R1_22 RDA/R1_32 RDA/R1_9 RDA/R1_20 RDA/R1_32 RDA/R1_42 RDA/R1_30
+ RDA/R1_42 RDA/R1_40 RDA/R2_9 RDA/R2_9 xq1/X CM1/C1 RDA/R2_5 RDA/R2_5 RDA/R2_3 RDA/R2_3
+ xq0/X xq3/X RIN/B CM1/C1 RDA/R2_29 RDA/R2_17 RDA/R2_29 RDA/R2_39 RDA/R2_17 RDA/R2_27
+ RDA/R2_39 RDA/R2_15 RDA/R2_27 xq6/X RDA/R2_15 xq4/X CM1/C1 xq2/X CM1/C1 RDA/R2_35
+ CM1/C1 RDA/R2_23 RDA/R2_35 RDA/R1_9 RDA/R2_23 RDA/R2_33 RDA/R2_11 RDA/R1_8 RDA/R2_21
+ RDA/R2_33 RIN/B RDA/R2_11 RDA/R1_8 RDA/R2_21 xq5/X CM1/C1 RDA/R1_6 CM1/C1 RDA/R2_41
+ RDA/R1_6 RDA/R2_41 RDA/R1_20 sky130_fd_pr__res_xhigh_po_0p35_Z9GLRM
XRIN RIN/R1_1 RIN/R1_1 RIN/B CM1/C1 RIN/R2_0 sky130_fd_pr__res_xhigh_po_0p35_Y3K97R
Xmon xq3/VPB RIN/B mon/X mon/A xq3/VPB RIN/B mon/a_27_47# sky130_fd_sc_hd__buf_4
XCM0 CM1/C1 CM1/C2 RIN/B sky130_fd_pr__cap_mim_m3_1_4SMZ5E
XCM1 CM1/C1 CM1/C2 RIN/B sky130_fd_pr__cap_mim_m3_1_4SMZ5E
Xdq1 xq1/B dq6/CLK xq1/A xq1/VPB RIN/B xq1/VPB RIN/B dq1/a_891_413# dq1/a_466_413#
+ dq1/a_1059_315# dq1/a_193_47# dq1/a_634_159# dq1/a_381_47# dq1/a_27_47# sky130_fd_sc_hd__dfxtp_1
Xdq0 xq0/B dq6/CLK xq0/A xq1/VPB RIN/B xq1/VPB RIN/B dq0/a_891_413# dq0/a_466_413#
+ dq0/a_1059_315# dq0/a_193_47# dq0/a_634_159# dq0/a_381_47# dq0/a_27_47# sky130_fd_sc_hd__dfxtp_1
Xdq2 xq2/B dq6/CLK xq2/A xq3/VPB RIN/B xq3/VPB RIN/B dq2/a_891_413# dq2/a_466_413#
+ dq2/a_1059_315# dq2/a_193_47# dq2/a_634_159# dq2/a_381_47# dq2/a_27_47# sky130_fd_sc_hd__dfxtp_1
Xdq3 xq3/B dq6/CLK xq3/A xq3/VPB RIN/B xq3/VPB RIN/B dq3/a_891_413# dq3/a_466_413#
+ dq3/a_1059_315# dq3/a_193_47# dq3/a_634_159# dq3/a_381_47# dq3/a_27_47# sky130_fd_sc_hd__dfxtp_1
Xdq4 xq4/B dq6/CLK xq4/A xq5/VPB RIN/B xq5/VPB RIN/B dq4/a_891_413# dq4/a_466_413#
+ dq4/a_1059_315# dq4/a_193_47# dq4/a_634_159# dq4/a_381_47# dq4/a_27_47# sky130_fd_sc_hd__dfxtp_1
Xxq0 RIN/B xq1/VPB xq1/VPB RIN/B xq0/A xq0/X xq0/B xq0/a_285_297# xq0/a_35_297# sky130_fd_sc_hd__xor2_1
Xdq5 xq5/B dq6/CLK xq5/A xq5/VPB RIN/B xq5/VPB RIN/B dq5/a_891_413# dq5/a_466_413#
+ dq5/a_1059_315# dq5/a_193_47# dq5/a_634_159# dq5/a_381_47# dq5/a_27_47# sky130_fd_sc_hd__dfxtp_1
Xxq1 RIN/B xq1/VPB xq1/VPB RIN/B xq1/A xq1/X xq1/B xq1/a_285_297# xq1/a_35_297# sky130_fd_sc_hd__xor2_1
Xdq6 xq6/B dq6/CLK xq6/A xq6/VPB RIN/B xq6/VPB RIN/B dq6/a_891_413# dq6/a_466_413#
+ dq6/a_1059_315# dq6/a_193_47# dq6/a_634_159# dq6/a_381_47# dq6/a_27_47# sky130_fd_sc_hd__dfxtp_1
Xdff0 RIN/B xq3/VPB RIN/B xq3/VPB xq0/A mon/A dff6/CLK dff0/a_891_413# dff0/a_193_47#
+ dff0/a_381_47# dff0/a_1062_300# dff0/a_475_413# dff0/a_634_183# dff0/a_27_47# sky130_fd_sc_hd__dfxtp_4
Xxq2 RIN/B xq3/VPB xq3/VPB RIN/B xq2/A xq2/X xq2/B xq2/a_285_297# xq2/a_35_297# sky130_fd_sc_hd__xor2_1
Xdff1 RIN/B xq3/VPB RIN/B xq3/VPB xq1/A dff1/D dff6/CLK dff1/a_891_413# dff1/a_193_47#
+ dff1/a_381_47# dff1/a_1062_300# dff1/a_475_413# dff1/a_634_183# dff1/a_27_47# sky130_fd_sc_hd__dfxtp_4
Xxq3 RIN/B xq3/VPB xq3/VPB RIN/B xq3/A xq3/X xq3/B xq3/a_285_297# xq3/a_35_297# sky130_fd_sc_hd__xor2_1
X0 dff1/D mon/A a_2366_39596# w_440_39556# sky130_fd_pr__pfet_01v8 ad=0.33 pd=2.66 as=0.15 ps=1.3 w=1 l=0.15
X1 CM1/C2 a_3032_27474# w_2846_27270# w_2846_27270# sky130_fd_pr__pfet_01v8 ad=0.74 pd=4.37 as=1.32 ps=8.66 w=4 l=1
X2 dff6/D dff1/D a_2846_39596# w_440_39556# sky130_fd_pr__pfet_01v8 ad=0.33 pd=2.66 as=0.15 ps=1.3 w=1 l=0.15
X3 mon/A dff5/D a_1886_39236# RIN/B sky130_fd_pr__nfet_01v8 ad=0.165 pd=1.66 as=0.075 ps=0.8 w=0.5 l=0.15
X4 CM1/C1 a_4654_26861# CM1/C2 RIN/B sky130_fd_pr__nfet_01v8 ad=0.1386 pd=1.5 as=0.1386 ps=1.5 w=0.42 l=0.15
X5 mon/A dff5/D a_1886_39596# w_440_39556# sky130_fd_pr__pfet_01v8 ad=0.33 pd=2.66 as=0.15 ps=1.3 w=1 l=0.15
X6 a_2306_26380# a_1906_26237# RIN/B RIN/B sky130_fd_pr__nfet_01v8 ad=0.37 pd=2.37 as=0.66 ps=4.66 w=2 l=2
X7 RIN/B dff5/D RIN/B RIN/B sky130_fd_pr__nfet_01v8 ad=0.49 pd=3.5 as=22.80923 ps=225.33 w=1.4 l=2.86
X8 w_2846_27270# a_3032_27474# a_3032_27474# w_2846_27270# sky130_fd_pr__pfet_01v8 ad=1.32 pd=8.66 as=0.74 ps=4.37 w=4 l=1
X9 a_3326_39236# a_1066_39096# RIN/B RIN/B sky130_fd_pr__nfet_01v8 ad=0.075 pd=0.8 as=0.165 ps=1.66 w=0.5 l=1
X10 a_3806_39236# a_1066_39096# RIN/B RIN/B sky130_fd_pr__nfet_01v8 ad=0.075 pd=0.8 as=0.165 ps=1.66 w=0.5 l=1
X11 a_586_39570# CM1/C2 a_520_37976# RIN/B sky130_fd_pr__nfet_01v8 ad=1.32 pd=8.66 as=1.32 ps=8.66 w=4 l=1
X12 a_3326_39596# a_586_39570# w_440_39556# w_440_39556# sky130_fd_pr__pfet_01v8 ad=0.15 pd=1.3 as=0.33 ps=2.66 w=1 l=1
X13 a_2366_39236# a_1066_39096# RIN/B RIN/B sky130_fd_pr__nfet_01v8 ad=0.075 pd=0.8 as=0.165 ps=1.66 w=0.5 l=1
X14 a_2366_39596# a_586_39570# w_440_39556# w_440_39556# sky130_fd_pr__pfet_01v8 ad=0.15 pd=1.3 as=0.33 ps=2.66 w=1 l=1
X15 a_3806_39596# a_586_39570# w_440_39556# w_440_39556# sky130_fd_pr__pfet_01v8 ad=0.15 pd=1.3 as=0.33 ps=2.66 w=1 l=1
X16 a_2846_39236# a_1066_39096# RIN/B RIN/B sky130_fd_pr__nfet_01v8 ad=0.075 pd=0.8 as=0.165 ps=1.66 w=0.5 l=1
X17 a_3032_27474# a_3032_26237# a_2306_26380# RIN/B sky130_fd_pr__nfet_01v8 ad=0.74 pd=4.37 as=1.32 ps=8.66 w=4 l=1
X18 a_2306_26380# CM1/C1 CM1/C2 RIN/B sky130_fd_pr__nfet_01v8 ad=1.32 pd=8.66 as=0.74 ps=4.37 w=4 l=1
X19 a_2846_39596# a_586_39570# w_440_39556# w_440_39556# sky130_fd_pr__pfet_01v8 ad=0.15 pd=1.3 as=0.33 ps=2.66 w=1 l=1
X20 a_1886_39236# a_1066_39096# RIN/B RIN/B sky130_fd_pr__nfet_01v8 ad=0.075 pd=0.8 as=0.165 ps=1.66 w=0.5 l=1
X21 a_1886_39596# a_586_39570# w_440_39556# w_440_39556# sky130_fd_pr__pfet_01v8 ad=0.15 pd=1.3 as=0.33 ps=2.66 w=1 l=1
X22 a_1066_39096# a_1066_39096# RIN/B RIN/B sky130_fd_pr__nfet_01v8 ad=0.165 pd=1.66 as=0.165 ps=1.66 w=0.5 l=1
X23 CM1/C2 CM1/C1 a_2306_26380# RIN/B sky130_fd_pr__nfet_01v8 ad=0.74 pd=4.37 as=1.32 ps=8.66 w=4 l=1
X24 a_1066_39096# a_586_39570# w_440_39556# w_440_39556# sky130_fd_pr__pfet_01v8 ad=0.33 pd=2.66 as=0.33 ps=2.66 w=1 l=1
X25 RIN/B dff4/D RIN/B RIN/B sky130_fd_pr__nfet_01v8 ad=0.49 pd=3.5 as=0 ps=0 w=1.4 l=2.86
X26 RIN/B a_1906_26237# a_2306_26380# RIN/B sky130_fd_pr__nfet_01v8 ad=0.66 pd=4.66 as=0.37 ps=2.37 w=2 l=2
X27 RIN/B dff2/D RIN/B RIN/B sky130_fd_pr__nfet_01v8 ad=0.49 pd=3.5 as=0 ps=0 w=1.4 l=2.86
X28 dff4/D dff3/D a_4286_39236# RIN/B sky130_fd_pr__nfet_01v8 ad=0.165 pd=1.66 as=0.075 ps=0.8 w=0.5 l=0.15
X29 RIN/B dff3/D RIN/B RIN/B sky130_fd_pr__nfet_01v8 ad=0.49 pd=3.5 as=0 ps=0 w=1.4 l=2.86
X30 dff5/D dff4/D a_4766_39236# RIN/B sky130_fd_pr__nfet_01v8 ad=0.165 pd=1.66 as=0.075 ps=0.8 w=0.5 l=0.15
X31 RIN/B dff1/D RIN/B RIN/B sky130_fd_pr__nfet_01v8 ad=0.49 pd=3.5 as=0 ps=0 w=1.4 l=2.86
X32 a_586_39570# a_586_39570# w_440_39556# w_440_39556# sky130_fd_pr__pfet_01v8 ad=0.33 pd=2.66 as=0.33 ps=2.66 w=1 l=1
X33 dff4/D dff3/D a_4286_39596# w_440_39556# sky130_fd_pr__pfet_01v8 ad=0.33 pd=2.66 as=0.15 ps=1.3 w=1 l=0.15
X34 dff2/D dff6/D a_3326_39236# RIN/B sky130_fd_pr__nfet_01v8 ad=0.165 pd=1.66 as=0.075 ps=0.8 w=0.5 l=0.15
X35 RIN/B dff6/D RIN/B RIN/B sky130_fd_pr__nfet_01v8 ad=0.49 pd=3.5 as=0 ps=0 w=1.4 l=2.86
X36 a_2306_26380# a_3032_26237# a_3032_27474# RIN/B sky130_fd_pr__nfet_01v8 ad=1.32 pd=8.66 as=0.74 ps=4.37 w=4 l=1
X37 dff2/D dff6/D a_3326_39596# w_440_39556# sky130_fd_pr__pfet_01v8 ad=0.33 pd=2.66 as=0.15 ps=1.3 w=1 l=0.15
X38 dff5/D dff4/D a_4766_39596# w_440_39556# sky130_fd_pr__pfet_01v8 ad=0.33 pd=2.66 as=0.15 ps=1.3 w=1 l=0.15
X39 dff3/D dff2/D a_3806_39236# RIN/B sky130_fd_pr__nfet_01v8 ad=0.165 pd=1.66 as=0.075 ps=0.8 w=0.5 l=0.15
X40 dff3/D dff2/D a_3806_39596# w_440_39556# sky130_fd_pr__pfet_01v8 ad=0.33 pd=2.66 as=0.15 ps=1.3 w=1 l=0.15
X41 a_4286_39236# a_1066_39096# RIN/B RIN/B sky130_fd_pr__nfet_01v8 ad=0.075 pd=0.8 as=0.165 ps=1.66 w=0.5 l=1
X42 a_4286_39596# a_586_39570# w_440_39556# w_440_39556# sky130_fd_pr__pfet_01v8 ad=0.15 pd=1.3 as=0.33 ps=2.66 w=1 l=1
X43 a_4766_39236# a_1066_39096# RIN/B RIN/B sky130_fd_pr__nfet_01v8 ad=0.075 pd=0.8 as=0.165 ps=1.66 w=0.5 l=1
X44 a_4766_39596# a_586_39570# w_440_39556# w_440_39556# sky130_fd_pr__pfet_01v8 ad=0.15 pd=1.3 as=0.33 ps=2.66 w=1 l=1
X45 w_2846_27270# a_3032_27474# CM1/C2 w_2846_27270# sky130_fd_pr__pfet_01v8 ad=1.32 pd=8.66 as=0.74 ps=4.37 w=4 l=1
X46 a_3032_27474# a_3032_27474# w_2846_27270# w_2846_27270# sky130_fd_pr__pfet_01v8 ad=0.74 pd=4.37 as=1.32 ps=8.66 w=4 l=1
X47 dff1/D mon/A a_2366_39236# RIN/B sky130_fd_pr__nfet_01v8 ad=0.165 pd=1.66 as=0.075 ps=0.8 w=0.5 l=0.15
X48 dff6/D dff1/D a_2846_39236# RIN/B sky130_fd_pr__nfet_01v8 ad=0.165 pd=1.66 as=0.075 ps=0.8 w=0.5 l=0.15
X49 RIN/B mon/A RIN/B RIN/B sky130_fd_pr__nfet_01v8 ad=0.49 pd=3.5 as=0 ps=0 w=1.4 l=2.86
C0 dff6/CLK dff5/a_27_47# 0.03089f
C1 xq1/X xq0/X 9.0393f
C2 xq0/A dff6/CLK 1.0047f
C3 xq3/VPB dff0/a_27_47# 0.0594f
C4 CM1/C1 RDA/R2_3 0.01627f
C5 a_586_39570# a_520_37976# 0.08048f
C6 CM1/C1 RDA/R2_9 0.01627f
C7 xq3/X xq6/VPB 0.02886f
C8 dq6/CLK dq4/a_27_47# 0.02678f
C9 dq3/a_27_47# dq2/a_27_47# 0.03757f
C10 dff4/D dff0/a_27_47# 0.04763f
C11 xq0/A dq0/a_634_159# 0.01899f
C12 dff3/D dff6/a_193_47# 0.01617f
C13 dff6/CLK dff2/a_193_47# 0.08286f
C14 xq3/X xq1/X 0.10651f
C15 xq2/B xq2/A 0.09776f
C16 dff5/a_193_47# xq1/A 0.02061f
C17 dq0/a_891_413# dq1/a_891_413# 0.01464f
C18 xq5/B xq6/B 0.02479f
C19 a_586_39570# w_440_39556# 4.10394f
C20 dq2/a_193_47# xq2/A 0.07828f
C21 dff3/D dff3/a_381_47# 0.01227f
C22 dff3/a_891_413# xq1/A 0.01267f
C23 mon/A dff0/a_27_47# 0.08754f
C24 xq4/A dq4/a_466_413# 0.0151f
C25 dff4/a_27_47# xq1/VPB 0.05835f
C26 dq6/CLK xq2/A 0.41073f
C27 dff4/a_193_47# dff6/CLK 0.06437f
C28 dq6/a_1059_315# dq5/a_1059_315# 0.02513f
C29 RDA/R2_33 CM1/C1 0.01627f
C30 RDA/R2_41 CM1/C1 0.01655f
C31 dq4/a_193_47# xq4/A 0.07787f
C32 dff3/a_27_47# dff6/CLK 0.03433f
C33 dq1/a_1059_315# xq1/A 0.03011f
C34 a_2306_26380# CM1/C1 0.69454f
C35 xq1/VPB dff3/a_1062_300# 0.02558f
C36 xq6/A xq6/a_35_297# 0.02709f
C37 xq1/B dq1/a_1059_315# 0.02886f
C38 xq0/A dff0/a_27_47# 0.01512f
C39 dff6/CLK xq2/A 0.15721f
C40 dff1/D w_440_39556# 0.33628f
C41 dq0/a_634_159# dq1/a_634_159# 0.01245f
C42 xq2/a_35_297# xq2/B 0.17659f
C43 xq6/X xq5/X 6.41071f
C44 mon/a_27_47# dff2/a_475_413# 0.01337f
C45 CM1/C1 a_3032_27474# 0.03469f
C46 dff6/CLK dff6/D 0.14436f
C47 a_1066_39096# dff3/D 0.10762f
C48 a_2306_26380# a_1906_26237# 0.3085f
C49 xq5/VPB xq3/VPB 0.02013f
C50 dq5/a_891_413# dq6/a_891_413# 0.01593f
C51 xq5/A xq1/VPB 0.19906f
C52 xq6/X xq0/X 0.12351f
C53 xq4/A xq1/VPB 0.20486f
C54 dq0/a_27_47# xq0/A 0.05395f
C55 dq6/a_193_47# xq6/A 0.07768f
C56 RIN/R2_0 xq4/X 0.05501f
C57 dff3/a_634_183# dff5/D 0.02103f
C58 xq6/VPB xq6/A 0.14381f
C59 w_2846_27270# CM1/C1 0.15229f
C60 dff5/D dff3/a_1062_300# 0.01128f
C61 dff6/CLK dff2/D 0.37947f
C62 dff2/a_27_47# xq1/VPB 0.05525f
C63 dff1/a_475_413# dff3/D 0.02248f
C64 xq6/X xq3/X 0.10727f
C65 dff2/a_381_47# dff2/D 0.01227f
C66 dq6/CLK dq3/a_27_47# 0.02678f
C67 dq6/CLK xq6/A 1.41229f
C68 xq6/B xq6/a_35_297# 0.17659f
C69 dff4/a_27_47# xq3/A 0.01274f
C70 dff1/a_891_413# xq1/A 0.0154f
C71 dff4/a_1062_300# xq1/VPB 0.02079f
C72 xq5/X CM1/C1 0.12687f
C73 dff2/a_634_183# dff4/D 0.02114f
C74 xq3/X xq3/a_285_297# 0.01864f
C75 dq1/a_27_47# xq0/A 0.01017f
C76 dq3/a_634_159# dq2/a_634_159# 0.01245f
C77 xq5/A dff5/D 0.01268f
C78 dff4/a_27_47# dff4/D 0.07808f
C79 dq2/a_891_413# dq3/a_891_413# 0.01464f
C80 xq4/A dff5/D 0.02024f
C81 CM1/C1 xq0/X 1.81896f
C82 xq5/B dq5/a_1059_315# 0.02886f
C83 dff0/a_891_413# dff4/D 0.02028f
C84 dff3/a_634_183# dff6/a_1062_300# 0.01389f
C85 dff5/a_381_47# dff5/D 0.01244f
C86 dq3/a_466_413# dq4/a_466_413# 0.01385f
C87 xq4/A dq4/a_634_159# 0.01911f
C88 xq5/X xq5/VPB 0.32365f
C89 dq2/a_891_413# xq2/A 0.02236f
C90 dff4/a_891_413# dff6/CLK 0.02031f
C91 xq1/B xq1/A 0.09776f
C92 xq6/B xq6/VPB 0.03493f
C93 xq3/B dq3/a_1059_315# 0.02886f
C94 xq3/X CM1/C1 0.12748f
C95 xq5/A xq3/A 0.75366f
C96 xq1/a_35_297# xq2/a_35_297# 0.01594f
C97 dff2/D dff0/a_27_47# 0.05572f
C98 CM1/C2 CM1/C1 2.42632f
C99 dq0/a_381_47# xq0/A 0.01348f
C100 xq5/VPB xq0/X 0.06639f
C101 xq4/A xq3/A 3.93592f
C102 xq5/A xq3/VPB 0.03017f
C103 dff1/D dff6/CLK 0.03781f
C104 xq4/A xq3/VPB 0.03347f
C105 xq5/VPB dq4/a_27_47# 0.0501f
C106 dff6/a_27_47# dff2/a_1062_300# 0.01191f
C107 xq0/A dq0/a_193_47# 0.0775f
C108 dff4/a_27_47# xq0/A 0.02734f
C109 xq6/VPB xq2/X 0.02891f
C110 xq5/VPB xq3/X 0.02778f
C111 a_3032_26237# a_2306_26380# 0.42401f
C112 dff3/a_475_413# dff5/D 0.02909f
C113 dff2/a_27_47# dff4/D 0.05553f
C114 xq1/X xq2/X 8.38096f
C115 CM1/C2 a_1906_26237# 1.17998f
C116 dq3/a_891_413# dq4/a_891_413# 0.01593f
C117 dff3/a_193_47# xq1/A 0.01526f
C118 dff4/a_1062_300# xq3/A 0.0128f
C119 xq0/A dff0/a_891_413# 0.01442f
C120 dff6/CLK mon/a_27_47# 0.04332f
C121 dq1/a_193_47# dq0/a_193_47# 0.0272f
C122 xq5/A xq5/a_35_297# 0.02709f
C123 dff3/D xq1/VPB 0.02292f
C124 a_1066_39096# dff5/D 0.3245f
C125 a_3032_26237# a_3032_27474# 0.36889f
C126 dq6/a_27_47# xq6/A 0.0553f
C127 dff3/D dff6/a_891_413# 0.03082f
C128 dff6/a_27_47# dff2/a_891_413# 0.01003f
C129 dff1/a_475_413# dff5/D 0.01162f
C130 dff4/a_27_47# dff4/a_193_47# -0.01246f
C131 xq5/A dff5/a_27_47# 0.01165f
C132 xq5/A xq0/A 0.09259f
C133 a_3032_26237# w_2846_27270# 0.13591f
C134 xq4/A xq0/A 0.07757f
C135 dff1/a_1062_300# xq1/A 0.05005f
C136 dq0/a_466_413# dq1/a_466_413# 0.01384f
C137 xq0/A dff2/a_27_47# 0.01492f
C138 dff3/D dff5/D 0.34741f
C139 xq2/X xq2/a_285_297# 0.01866f
C140 a_1066_39096# dff4/D 0.0905f
C141 xq5/A xq0/X 0.0179f
C142 dff0/a_475_413# mon/A 0.02815f
C143 xq4/A xq0/X 0.0179f
C144 xq5/A dq4/a_27_47# 0.01218f
C145 dff6/CLK dff6/a_27_47# 0.048f
C146 dq6/CLK dq5/a_27_47# 0.02678f
C147 dff2/a_27_47# dff2/a_193_47# -0.01246f
C148 RDA/R2_35 CM1/C1 0.01655f
C149 xq6/A dq6/a_381_47# 0.01362f
C150 xq4/A dq4/a_27_47# 0.05564f
C151 xq1/B xq2/B 0.02479f
C152 dff4/a_1062_300# xq0/A 0.02077f
C153 dff4/a_475_413# dff6/CLK 0.02241f
C154 xq5/X xq4/X 7.12348f
C155 dff6/a_381_47# dff6/D 0.01244f
C156 dq6/CLK xq1/A 0.3522f
C157 xq3/A dq3/a_466_413# 0.01596f
C158 mon/X xq1/VPB 0.03735f
C159 dff1/a_634_183# dff5/D 0.02122f
C160 a_1066_39096# mon/A 0.1269f
C161 xq5/VPB xq6/A 0.0422f
C162 xq5/A dff3/a_27_47# 0.01026f
C163 xq6/X xq2/X 0.10646f
C164 dff3/D xq3/VPB 0.13328f
C165 RDA/R2_11 CM1/C1 0.01655f
C166 xq0/X xq4/X 0.12047f
C167 dff3/D dff4/D 1.25808f
C168 xq5/A xq2/A 0.39874f
C169 xq4/A xq2/A 0.06094f
C170 xq4/A dff5/a_1062_300# 0.03254f
C171 a_3032_26237# CM1/C2 0.3574f
C172 dff6/a_193_47# xq2/A 0.01075f
C173 dff3/D dff6/a_1062_300# 0.03463f
C174 xq3/X xq4/X 7.3939f
C175 dq6/CLK dq2/a_27_47# 0.02678f
C176 dff4/a_381_47# dff4/D 0.01244f
C177 dff6/a_193_47# dff6/D 0.0509f
C178 dff6/CLK dff2/a_475_413# 0.02027f
C179 dff1/a_27_47# dff3/D 0.05521f
C180 xq1/VPB dff5/D 0.1691f
C181 dff4/D dff0/a_193_47# 0.04895f
C182 dq1/a_634_159# dq2/a_634_159# 0.01366f
C183 dq1/a_466_413# dq2/a_466_413# 0.01385f
C184 xq2/A dq2/a_634_159# 0.01943f
C185 CM1/C1 xq2/X 0.12834f
C186 xq0/B xq1/VPB 0.03413f
C187 dq0/a_1059_315# xq0/B 0.02886f
C188 dff0/a_1062_300# xq3/VPB 0.01526f
C189 dff0/a_634_183# dff4/D 0.01722f
C190 dq3/a_634_159# dq4/a_634_159# 0.01366f
C191 dq2/a_193_47# dq3/a_193_47# 0.0272f
C192 dff6/CLK dff6/a_634_183# 0.01946f
C193 dff3/a_193_47# dff6/CLK 0.02259f
C194 xq1/a_35_297# xq1/A 0.02709f
C195 dff2/a_27_47# dff2/D 0.04436f
C196 dff0/a_1062_300# dff4/D 0.02264f
C197 a_4654_26861# CM1/C1 0.42886f
C198 RIN/R2_0 a_3032_27474# 0.15057f
C199 mon/A dff0/a_193_47# 0.11789f
C200 xq1/B xq1/a_35_297# 0.17659f
C201 xq3/A xq1/VPB 0.2438f
C202 mon/X xq3/VPB 0.18812f
C203 dq3/a_634_159# xq3/A 0.01954f
C204 dff6/CLK dff2/a_1062_300# 0.0648f
C205 xq5/A xq6/A 4.16104f
C206 xq5/VPB xq2/X 0.02645f
C207 xq3/VPB xq1/VPB 0.04141f
C208 dq5/a_27_47# dq6/a_27_47# 0.0407f
C209 xq4/A xq6/A 0.39525f
C210 dff0/a_634_183# mon/A 0.02046f
C211 mon/X dff4/D 0.12115f
C212 xq1/VPB dff4/D 0.16206f
C213 w_2846_27270# RIN/R2_0 0.13991f
C214 a_1906_26237# a_4654_26861# 2.06397f
C215 xq0/a_35_297# xq0/B 0.17659f
C216 a_1066_39096# dff6/D 0.1109f
C217 xq4/a_35_297# xq4/B 0.17659f
C218 dff0/a_475_413# dff2/D 0.01854f
C219 xq5/A dff4/a_891_413# 0.01224f
C220 dq0/a_27_47# xq1/A 0.01756f
C221 xq6/VPB xq1/X 0.02903f
C222 RDA/R2_29 CM1/C1 0.01655f
C223 dq6/CLK xq6/VPB 0.10719f
C224 dff3/a_27_47# dff3/D 0.04436f
C225 mon/A mon/X 0.06382f
C226 dff0/a_1062_300# xq0/A 0.03333f
C227 xq5/X RIN/R2_0 0.08313f
C228 dq1/a_466_413# xq1/A 0.01667f
C229 xq4/A xq4/a_35_297# 0.02709f
C230 a_1066_39096# dff2/D 0.10842f
C231 xq3/B xq2/B 0.02433f
C232 dff6/CLK dff2/a_891_413# 0.02687f
C233 dff3/D xq2/A 0.09281f
C234 xq3/VPB dff5/D 0.16441f
C235 dff4/D dff5/D 1.35777f
C236 dq3/a_1059_315# dq4/a_1059_315# 0.02513f
C237 RIN/R2_0 xq0/X 0.03727f
C238 xq0/A mon/X 0.76094f
C239 dff3/D dff6/D 0.04175f
C240 dff6/a_1062_300# dff5/D 0.03989f
C241 xq1/VPB dff5/a_27_47# 0.05977f
C242 dq0/a_891_413# xq0/A 0.02207f
C243 xq0/A xq1/VPB 0.25806f
C244 dq1/a_27_47# xq1/A 0.0615f
C245 xq0/A dq0/a_1059_315# 0.02906f
C246 dq6/CLK dff6/CLK 0.16129f
C247 xq5/VPB dq5/a_27_47# 0.0501f
C248 xq5/A dq5/a_381_47# 0.01382f
C249 xq5/B xq5/VPB 0.03413f
C250 xq3/A dq3/a_381_47# 0.01402f
C251 xq3/X RIN/R2_0 0.04014f
C252 xq3/VPB xq3/A 0.21054f
C253 mon/A dff5/D 0.18554f
C254 a_586_39570# a_1066_39096# 0.19517f
C255 CM1/C2 RIN/R2_0 1.24864f
C256 dff1/a_27_47# dff5/D 0.05275f
C257 xq0/X xq1/VPB 0.28048f
C258 dff3/D dff2/D 0.90522f
C259 xq3/A dff4/D 0.02072f
C260 dff6/CLK dff2/a_381_47# 0.01307f
C261 xq3/VPB dff4/D 0.13509f
C262 xq3/a_35_297# xq3/A 0.02709f
C263 dq1/a_27_47# dq2/a_27_47# 0.0407f
C264 dff4/a_634_183# dff6/CLK 0.01586f
C265 a_2306_26380# a_3032_27474# 0.53059f
C266 xq3/VPB dff6/a_1062_300# 0.02168f
C267 xq0/a_35_297# xq0/A 0.02709f
C268 xq0/a_285_297# xq0/X 0.02272f
C269 dff5/D dff5/a_27_47# 0.07808f
C270 dff4/a_193_47# xq1/VPB 0.01044f
C271 xq0/A dff5/D 0.0108f
C272 dq1/a_891_413# xq1/A 0.02303f
C273 dff3/a_27_47# xq1/VPB 0.05763f
C274 dq0/a_193_47# xq1/A 0.01279f
C275 dff1/D a_1066_39096# 0.11111f
C276 xq6/X xq6/VPB 0.38917f
C277 dff0/a_1062_300# dff6/D 0.04023f
C278 xq0/A xq0/B 0.09776f
C279 dff6/CLK dff6/a_475_413# 0.0188f
C280 a_3032_26237# a_4654_26861# 0.34111f
C281 dff2/D dff0/a_193_47# 0.06079f
C282 xq2/X xq4/X 0.10631f
C283 mon/A xq3/VPB 0.1416f
C284 dff1/a_27_47# xq3/VPB 0.06475f
C285 a_586_39570# dff3/D 0.13157f
C286 w_2846_27270# a_2306_26380# 0.12148f
C287 xq1/VPB xq2/A 0.08772f
C288 xq6/X xq1/X 0.10624f
C289 dff5/a_1062_300# xq1/VPB 0.01793f
C290 dq6/a_193_47# dq5/a_193_47# 0.0272f
C291 mon/A dff4/D 0.38739f
C292 xq5/B xq4/B 0.02433f
C293 dff6/a_193_47# dff6/a_27_47# -0.01246f
C294 xq5/A dq5/a_466_413# 0.0151f
C295 dff3/a_1062_300# xq1/A 0.01793f
C296 dq6/a_891_413# xq6/A 0.02207f
C297 xq6/VPB dq6/a_27_47# 0.04881f
C298 mon/X dff6/D 0.0106f
C299 dff1/a_27_47# dff6/a_1062_300# 0.01095f
C300 xq0/A xq3/A 0.59314f
C301 dff6/a_891_413# xq2/A 0.01406f
C302 w_2846_27270# a_3032_27474# 2.46694f
C303 xq0/A xq3/VPB 0.22887f
C304 dff6/CLK dff0/a_27_47# 0.08021f
C305 xq5/A dq5/a_27_47# 0.05671f
C306 dq6/CLK dq6/a_27_47# 0.02528f
C307 xq4/A dq5/a_27_47# 0.01017f
C308 xq5/B xq5/A 0.09776f
C309 xq0/A dff4/D 0.12334f
C310 dff1/D dff3/D 0.24449f
C311 dff3/a_27_47# dff5/D 0.05556f
C312 dq6/CLK dq0/a_27_47# 0.02515f
C313 xq0/X xq3/A 0.0179f
C314 mon/X dff2/D 0.08268f
C315 xq5/A xq1/A 0.06183f
C316 xq1/VPB dff2/D 0.0216f
C317 CM1/C1 RDA/R2_5 0.01655f
C318 xq3/VPB xq0/X 0.06652f
C319 dff2/a_193_47# dff4/D 0.0554f
C320 xq4/A xq1/A 0.42539f
C321 xq2/A dff5/D 0.1978f
C322 xq5/A dq5/a_1059_315# 0.02906f
C323 xq5/A dq5/a_634_159# 0.01899f
C324 CM1/C1 xq1/X 0.13059f
C325 xq0/A mon/A 0.06409f
C326 xq3/A dq3/a_891_413# 0.02221f
C327 dff6/D dff5/D 0.12336f
C328 dff1/a_193_47# dff3/D 0.06104f
C329 dff4/a_193_47# xq3/A 0.0129f
C330 xq3/X xq3/VPB 0.27711f
C331 CM1/C2 a_2306_26380# 0.73707f
C332 dff3/a_27_47# xq3/A 0.01249f
C333 dq6/CLK dq1/a_27_47# 0.02678f
C334 mon/A dff2/a_193_47# 0.01254f
C335 xq1/VPB xq6/A 0.17062f
C336 dff4/a_193_47# dff4/D 0.05082f
C337 xq5/VPB xq6/VPB 0.02013f
C338 xq3/A xq2/A 3.91092f
C339 xq0/A dff5/a_27_47# 0.0139f
C340 dq5/a_1059_315# dq4/a_1059_315# 0.02605f
C341 xq3/VPB xq2/A 0.31877f
C342 xq5/VPB xq1/X 0.0266f
C343 dq3/a_466_413# dq2/a_466_413# 0.01384f
C344 dff2/D dff5/D 0.12333f
C345 CM1/C2 a_3032_27474# 0.58072f
C346 dq6/CLK xq5/VPB 0.27772f
C347 xq2/A dff4/D 0.02675f
C348 xq0/A dff2/a_193_47# 0.01407f
C349 xq6/a_285_297# xq6/X 0.0186f
C350 dff6/a_1062_300# xq2/A 0.05329f
C351 xq3/VPB dff6/D 0.16383f
C352 CM1/C1 RDA/R2_23 0.01655f
C353 dq6/a_634_159# xq6/A 0.01899f
C354 dff6/D dff4/D 0.15195f
C355 xq4/a_285_297# xq4/X 0.01862f
C356 xq5/X xq0/X 0.12005f
C357 w_2846_27270# CM1/C2 0.83412f
C358 dff5/a_193_47# xq1/VPB 0.01044f
C359 dff0/a_1062_300# mon/a_27_47# 0.01029f
C360 dff3/D dff6/a_27_47# 0.01268f
C361 dff1/a_27_47# xq2/A 0.01046f
C362 a_586_39570# dff5/D 0.23205f
C363 xq3/VPB dff2/D 0.12265f
C364 dff4/a_193_47# xq0/A 0.02754f
C365 xq5/X xq3/X 0.1062f
C366 RIN/R2_0 xq2/X 0.0409f
C367 dff3/a_27_47# dff5/a_27_47# 0.01359f
C368 dff2/D dff4/D 0.44039f
C369 mon/A dff6/D 0.13353f
C370 mon/X mon/a_27_47# 0.01809f
C371 CM1/C1 RDA/R2_17 0.01655f
C372 dff6/CLK dff2/a_634_183# 0.01694f
C373 dq0/a_1059_315# dq1/a_1059_315# 0.02605f
C374 xq3/X xq0/X 0.12143f
C375 xq2/A dff5/a_27_47# 0.01273f
C376 dff4/a_27_47# dff6/CLK 0.09252f
C377 xq0/A xq2/A 0.24294f
C378 xq6/X CM1/C1 0.12675f
C379 dq3/a_27_47# xq3/A 0.05845f
C380 xq0/A dff5/a_1062_300# 0.02077f
C381 dq6/a_466_413# xq6/A 0.01481f
C382 xq3/A xq6/A 0.07104f
C383 xq2/a_35_297# xq3/a_35_297# 0.01441f
C384 dq3/a_27_47# xq3/VPB 0.0501f
C385 xq3/VPB xq6/A 0.04247f
C386 dq5/a_466_413# dq4/a_466_413# 0.01384f
C387 dff1/D dff5/D 0.12315f
C388 w_440_39556# a_1066_39096# 0.10549f
C389 dff5/a_193_47# dff5/D 0.05082f
C390 xq0/A dff6/D 0.08148f
C391 mon/A dff2/D 0.94195f
C392 dff6/CLK dff0/a_891_413# 0.01706f
C393 xq0/X xq2/A 0.0179f
C394 xq3/A dq3/a_1059_315# 0.02906f
C395 a_586_39570# dff4/D 0.11449f
C396 dq6/CLK xq5/A 0.80173f
C397 dff0/a_1062_300# dff6/a_27_47# 0.01014f
C398 dq6/CLK xq4/A 0.59373f
C399 xq3/B xq4/B 0.02479f
C400 dff1/a_193_47# dff5/D 0.0546f
C401 xq0/A dff2/D 0.02272f
C402 dq1/a_27_47# dq0/a_27_47# 0.03757f
C403 xq2/A dq2/a_1059_315# 0.02922f
C404 xq5/A dff6/CLK 0.45337f
C405 xq6/VPB xq4/X 0.02901f
C406 dff1/D xq3/VPB 0.01829f
C407 dff6/CLK dff6/a_193_47# 0.02544f
C408 dff3/a_27_47# xq2/A 0.01887f
C409 a_586_39570# mon/A 0.18645f
C410 w_440_39556# dff3/D 0.33455f
C411 dff2/a_193_47# dff2/D 0.08276f
C412 xq1/X xq4/X 0.1039f
C413 dff1/D dff4/D 0.07892f
C414 dff6/CLK dff2/a_27_47# 0.10428f
C415 dff3/a_193_47# dff3/D 0.08276f
C416 xq3/a_35_297# xq4/a_35_297# 0.01594f
C417 xq0/A xq6/A 0.10233f
C418 dq0/a_466_413# xq0/A 0.01481f
C419 dq2/a_381_47# xq2/A 0.01396f
C420 mon/a_27_47# xq3/VPB 0.09039f
C421 dff4/a_1062_300# dff6/CLK 0.07337f
C422 xq4/a_35_297# xq5/a_35_297# 0.01441f
C423 dq2/a_891_413# dq1/a_891_413# 0.01593f
C424 a_1906_26237# CM1/C1 0.45051f
C425 mon/a_27_47# dff4/D 0.0271f
C426 dff1/D mon/A 0.25919f
C427 dff1/D dff1/a_27_47# 0.04369f
C428 xq1/VPB xq1/A 0.25569f
C429 xq0/X xq6/A 0.0179f
C430 xq4/A dq4/a_381_47# 0.01377f
C431 xq3/VPB xq2/X 0.29288f
C432 dff0/a_381_47# mon/A 0.0127f
C433 dff0/a_475_413# dff6/CLK 0.01144f
C434 dq3/a_27_47# dq4/a_27_47# 0.0407f
C435 xq1/B xq1/VPB 0.03413f
C436 a_2306_26380# a_4654_26861# 0.10478f
C437 dff1/a_891_413# dff5/D 0.02556f
C438 dff5/a_193_47# dff5/a_27_47# -0.01246f
C439 xq0/A dff5/a_193_47# 0.01611f
C440 mon/A mon/a_27_47# 0.0521f
C441 RDA/R2_39 CM1/C1 0.01627f
C442 xq2/a_35_297# xq2/A 0.02709f
C443 dff1/a_193_47# dff1/a_27_47# -0.01246f
C444 dff6/D dff2/D 1.0936f
C445 dq4/a_193_47# dq3/a_193_47# 0.0272f
C446 dff5/a_891_413# xq4/A 0.01526f
C447 a_4654_26861# a_3032_27474# 0.06918f
C448 a_586_39570# CM1/C2 0.08084f
C449 xq5/A dq5/a_193_47# 0.07871f
C450 dq3/a_27_47# xq2/A 0.01017f
C451 dq3/a_1059_315# dq2/a_1059_315# 0.02605f
C452 xq2/A xq6/A 0.07042f
C453 dff5/D xq1/A 0.15723f
C454 dq5/a_466_413# dq6/a_466_413# 0.01385f
C455 dq6/a_634_159# dq5/a_634_159# 0.01366f
C456 xq3/VPB dff6/a_27_47# 0.06242f
C457 dff5/a_1062_300# xq6/A 0.03745f
C458 CM1/C1 RDA/R2_21 0.01627f
C459 xq6/X xq4/X 0.10981f
C460 w_2846_27270# a_4654_26861# 0.08866f
C461 a_586_39570# dff6/D 0.13733f
C462 xq1/B xq0/B 0.02433f
C463 dff3/a_193_47# dff6/a_891_413# 0.01276f
C464 xq1/VPB dff2/a_1062_300# 0.02498f
C465 xq5/X xq2/X 0.10374f
C466 dff6/CLK dff3/D 0.04613f
C467 dq5/a_634_159# dq4/a_634_159# 0.01245f
C468 xq3/A xq1/A 0.06193f
C469 dq1/a_381_47# xq1/A 0.01446f
C470 xq5/VPB xq4/B 0.03413f
C471 xq3/VPB xq1/A 0.22812f
C472 RDA/R2_15 CM1/C1 0.01627f
C473 xq0/X xq2/X 0.124f
C474 w_440_39556# dff5/D 0.57835f
C475 dq1/a_1059_315# dq2/a_1059_315# 0.02513f
C476 a_586_39570# dff2/D 0.13513f
C477 dff3/a_193_47# dff5/D 0.0554f
C478 a_3032_26237# CM1/C1 0.62564f
C479 dff6/a_1062_300# xq1/A 0.01094f
C480 dff1/D dff6/D 0.63189f
C481 RIN/R2_0 xq1/X 0.03301f
C482 xq5/A xq5/VPB 0.21072f
C483 xq5/B xq5/a_35_297# 0.17659f
C484 xq3/X xq2/X 8.07263f
C485 dff6/CLK dff0/a_193_47# 0.04812f
C486 xq0/A dff6/a_27_47# 0.02028f
C487 xq4/A xq5/VPB 0.15684f
C488 xq3/A dq2/a_27_47# 0.01412f
C489 CM1/C1 xq4/X 0.12708f
C490 xq3/VPB dq2/a_27_47# 0.0501f
C491 xq4/A dq4/a_891_413# 0.02207f
C492 dff4/a_475_413# xq0/A 0.01094f
C493 dff2/a_475_413# dff4/D 0.02907f
C494 dff1/D dff1/a_381_47# 0.01227f
C495 dff1/D dff2/D 0.08243f
C496 a_3032_26237# a_1906_26237# 2.33865f
C497 dq6/CLK mon/X 0.06652f
C498 CM1/C2 a_4654_26861# 2.5041f
C499 dff0/a_1062_300# dff6/CLK 0.06646f
C500 xq1/X xq1/VPB 0.23042f
C501 dq6/CLK xq1/VPB 0.29765f
C502 dff1/a_1062_300# dff5/D 0.0353f
C503 w_440_39556# dff4/D 0.33989f
C504 xq2/A dq2/a_466_413# 0.01539f
C505 xq5/VPB xq4/X 0.34018f
C506 xq1/a_285_297# xq1/X 0.01871f
C507 xq1/A dff5/a_27_47# 0.02039f
C508 xq0/A xq1/A 3.26564f
C509 xq3/A dff2/a_1062_300# 0.03402f
C510 dff6/CLK mon/X 1.06773f
C511 dff3/a_193_47# dff6/a_1062_300# 0.01098f
C512 dff6/CLK xq1/VPB 0.50994f
C513 a_4766_39596# dff5/D 0.01037f
C514 xq3/A dq3/a_193_47# 0.07981f
C515 dq5/a_27_47# dq4/a_27_47# 0.03757f
C516 dff4/a_27_47# dff2/a_27_47# 0.01359f
C517 xq4/A dff3/a_1062_300# 0.03272f
C518 dff1/D a_586_39570# 0.13562f
C519 w_440_39556# mon/A 0.46263f
C520 dq1/a_193_47# xq1/A 0.08223f
C521 xq0/X xq1/A 0.0179f
C522 dq6/a_1059_315# xq6/A 0.02906f
C523 dq5/a_891_413# dq4/a_891_413# 0.01464f
C524 dff0/a_27_47# dff0/a_193_47# -0.01246f
C525 dff6/a_27_47# xq2/A 0.01367f
C526 xq4/A xq4/B 0.09776f
C527 xq6/B xq6/A 0.09776f
C528 dff6/a_27_47# dff6/D 0.07813f
C529 xq2/B xq3/VPB 0.03413f
C530 xq3/A dff2/a_891_413# 0.01093f
C531 xq6/X RIN/R2_0 0.22364f
C532 xq5/A xq4/A 3.83212f
C533 dq4/a_193_47# dq5/a_193_47# 0.0272f
C534 xq5/a_35_297# xq6/a_35_297# 0.01594f
C535 dff6/CLK dff5/D 0.03585f
C536 dff3/a_27_47# xq1/A 0.01104f
C537 RDA/R2_27 CM1/C1 0.01627f
C538 dq2/a_193_47# xq3/A 0.01037f
C539 xq4/B dq4/a_1059_315# 0.02886f
C540 dq1/a_634_159# xq1/A 0.01985f
C541 xq2/A xq1/A 4.33356f
C542 CM1/C2 a_520_37976# 0.11109f
C543 dq6/CLK xq3/A 0.53983f
C544 xq3/VPB xq1/X 0.02822f
C545 mon/X dff0/a_27_47# 0.01404f
C546 xq0/A dff2/a_1062_300# 0.0113f
C547 dq6/CLK xq3/VPB 0.27821f
C548 dff4/a_1062_300# xq5/A 0.03803f
C549 dff1/D dff1/a_193_47# 0.07821f
C550 dff5/a_475_413# xq1/A 0.01246f
C551 xq4/A dq4/a_1059_315# 0.02906f
C552 dq6/a_1059_315# xq6/B 0.02886f
C553 dff6/CLK xq3/A 0.62702f
C554 dff6/CLK xq3/VPB 0.4301f
C555 xq3/B xq3/A 0.09776f
C556 xq5/X xq5/a_285_297# 0.01861f
C557 xq2/A dq2/a_27_47# 0.05619f
C558 xq3/B xq3/VPB 0.03413f
C559 dff6/CLK dff4/D 0.53376f
C560 CM1/C1 RIN/R2_0 0.20658f
C561 dq0/a_27_47# xq1/VPB 0.0501f
C562 xq1/a_35_297# xq0/a_35_297# 0.01441f
C563 xq5/A dq5/a_891_413# 0.02207f
C564 dff3/a_27_47# dff3/a_193_47# -0.01246f
C565 xq3/B xq3/a_35_297# 0.17659f
C566 dff3/a_193_47# xq2/A 0.01706f
C567 w_440_39556# dff6/D 0.34745f
C568 xq5/X xq6/VPB 0.03062f
C569 dff6/CLK mon/A 0.26022f
C570 dff1/a_27_47# dff6/CLK 0.03314f
C571 dq6/CLK xq0/A 0.53294f
C572 xq5/X xq1/X 0.10298f
C573 xq6/A xq1/A 0.07106f
C574 dq1/a_27_47# xq1/VPB 0.0501f
C575 xq6/VPB xq0/X 0.05752f
C576 dq1/a_193_47# dq2/a_193_47# 0.0272f
C577 w_440_39556# dff2/D 0.34216f
C578 dff2/a_1062_300# dff6/D 0.01399f
C579 xq2/B dq2/a_1059_315# 0.02886f
C580 a_4654_26861# RIN/B 2.97969f
C581 a_1906_26237# RIN/B 2.92238f
C582 a_2306_26380# RIN/B 1.54242f
C583 a_3032_26237# RIN/B 3.35237f
C584 a_3032_27474# RIN/B 1.10694f
C585 a_520_37976# RIN/B 0.35628f
C586 a_1066_39096# RIN/B 5.04505f
C587 a_586_39570# RIN/B 2.34816f
C588 w_2846_27270# RIN/B 10.92022f
C589 w_440_39556# RIN/B 10.16071f
C590 xq3/X RIN/B 1.61754f
C591 xq3/a_35_297# RIN/B 0.25274f
C592 xq1/A RIN/B 1.68262f
C593 dff1/D RIN/B 2.44967f
C594 dff1/a_381_47# RIN/B 0.0164f
C595 dff1/a_891_413# RIN/B 0.1612f
C596 dff1/a_1062_300# RIN/B 0.53253f
C597 dff1/a_475_413# RIN/B 0.13738f
C598 dff1/a_634_183# RIN/B 0.15022f
C599 dff1/a_193_47# RIN/B 0.27169f
C600 dff1/a_27_47# RIN/B 0.49817f
C601 xq2/a_35_297# RIN/B 0.25274f
C602 xq0/A RIN/B 3.47207f
C603 mon/A RIN/B 3.48695f
C604 dff6/CLK RIN/B 3.5041f
C605 dff0/a_381_47# RIN/B 0.0164f
C606 dff0/a_891_413# RIN/B 0.1612f
C607 dff0/a_1062_300# RIN/B 0.53158f
C608 dff0/a_475_413# RIN/B 0.13739f
C609 dff0/a_634_183# RIN/B 0.1503f
C610 dff0/a_193_47# RIN/B 0.27167f
C611 dff0/a_27_47# RIN/B 0.49858f
C612 xq6/B RIN/B 0.25342f
C613 xq6/VPB RIN/B 6.06325f
C614 xq6/A RIN/B 2.73132f
C615 dq6/a_381_47# RIN/B 0.01537f
C616 dq6/a_891_413# RIN/B 0.16087f
C617 dq6/a_1059_315# RIN/B 0.24994f
C618 dq6/a_466_413# RIN/B 0.13324f
C619 dq6/a_634_159# RIN/B 0.14231f
C620 dq6/a_193_47# RIN/B 0.27323f
C621 dq6/a_27_47# RIN/B 0.47896f
C622 xq1/a_35_297# RIN/B 0.25274f
C623 xq5/B RIN/B 0.24031f
C624 xq5/VPB RIN/B 6.79005f
C625 xq5/A RIN/B 1.82816f
C626 dq6/CLK RIN/B 6.85464f
C627 dq5/a_381_47# RIN/B 0.01537f
C628 dq5/a_891_413# RIN/B 0.16087f
C629 dq5/a_1059_315# RIN/B 0.24994f
C630 dq5/a_466_413# RIN/B 0.13324f
C631 dq5/a_634_159# RIN/B 0.14231f
C632 dq5/a_193_47# RIN/B 0.27323f
C633 dq5/a_27_47# RIN/B 0.47896f
C634 xq0/a_35_297# RIN/B 0.25292f
C635 xq4/B RIN/B 0.24031f
C636 xq4/A RIN/B 1.44321f
C637 dq4/a_381_47# RIN/B 0.01537f
C638 dq4/a_891_413# RIN/B 0.16087f
C639 dq4/a_1059_315# RIN/B 0.24994f
C640 dq4/a_466_413# RIN/B 0.13324f
C641 dq4/a_634_159# RIN/B 0.14231f
C642 dq4/a_193_47# RIN/B 0.27323f
C643 dq4/a_27_47# RIN/B 0.47896f
C644 xq3/B RIN/B 0.24031f
C645 xq3/A RIN/B 1.569f
C646 dq3/a_381_47# RIN/B 0.01537f
C647 dq3/a_891_413# RIN/B 0.16087f
C648 dq3/a_1059_315# RIN/B 0.24994f
C649 dq3/a_466_413# RIN/B 0.13324f
C650 dq3/a_634_159# RIN/B 0.14231f
C651 dq3/a_193_47# RIN/B 0.27323f
C652 dq3/a_27_47# RIN/B 0.47896f
C653 xq2/B RIN/B 0.24031f
C654 dq2/a_381_47# RIN/B 0.01537f
C655 dq2/a_891_413# RIN/B 0.16087f
C656 dq2/a_1059_315# RIN/B 0.24994f
C657 dq2/a_466_413# RIN/B 0.13324f
C658 dq2/a_634_159# RIN/B 0.14231f
C659 dq2/a_193_47# RIN/B 0.27323f
C660 dq2/a_27_47# RIN/B 0.47896f
C661 xq0/B RIN/B 0.25472f
C662 dq0/a_381_47# RIN/B 0.01537f
C663 dq0/a_891_413# RIN/B 0.16105f
C664 dq0/a_1059_315# RIN/B 0.2502f
C665 dq0/a_466_413# RIN/B 0.1332f
C666 dq0/a_634_159# RIN/B 0.14231f
C667 dq0/a_193_47# RIN/B 0.27359f
C668 dq0/a_27_47# RIN/B 0.4793f
C669 xq1/B RIN/B 0.24031f
C670 dq1/a_381_47# RIN/B 0.01537f
C671 dq1/a_891_413# RIN/B 0.16087f
C672 dq1/a_1059_315# RIN/B 0.24994f
C673 dq1/a_466_413# RIN/B 0.13324f
C674 dq1/a_634_159# RIN/B 0.14231f
C675 dq1/a_193_47# RIN/B 0.27323f
C676 dq1/a_27_47# RIN/B 0.47896f
C677 CM1/C1 RIN/B 14.55769f
C678 CM1/C2 RIN/B 28.56237f
C679 mon/X RIN/B 0.54823f
C680 mon/a_27_47# RIN/B 0.49783f
C681 RIN/R2_0 RIN/B 4.3632f
C682 RIN/R1_1 RIN/B 0.82495f
C683 RDA/R1_43 RIN/B 0.40066f $ **FLOATING
C684 RDA/R1_42 RIN/B 0.39774f
C685 RDA/R2_41 RIN/B 0.39767f
C686 RDA/R1_40 RIN/B 0.39779f
C687 RDA/R2_39 RIN/B 0.39753f
C688 RDA/R1_38 RIN/B 0.39779f
C689 RDA/R1_36 RIN/B 0.39774f
C690 RDA/R2_35 RIN/B 0.39771f
C691 RDA/R1_34 RIN/B 0.3977f
C692 RDA/R2_33 RIN/B 0.39776f
C693 RDA/R1_32 RIN/B 0.39766f
C694 RDA/R1_30 RIN/B 0.39758f
C695 RDA/R2_29 RIN/B 0.39778f
C696 RDA/R1_28 RIN/B 0.39768f
C697 RDA/R2_27 RIN/B 0.39773f
C698 RDA/R1_26 RIN/B 0.39772f
C699 RDA/R1_24 RIN/B 0.39777f
C700 RDA/R2_23 RIN/B 0.39764f
C701 RDA/R1_22 RIN/B 0.39791f
C702 RDA/R2_21 RIN/B 0.39764f
C703 RDA/R1_20 RIN/B 0.39777f
C704 RDA/R1_18 RIN/B 0.39772f
C705 RDA/R2_17 RIN/B 0.39773f
C706 RDA/R1_16 RIN/B 0.39496f
C707 RDA/R2_15 RIN/B 0.39778f
C708 xq2/X RIN/B 1.41427f
C709 RDA/R1_14 RIN/B 0.39269f
C710 RDA/R1_12 RIN/B 0.39471f
C711 RDA/R2_11 RIN/B 0.39776f
C712 RDA/R1_9 RIN/B 0.39321f
C713 RDA/R2_9 RIN/B 0.39771f
C714 xq1/X RIN/B 1.45846f
C715 RDA/R1_8 RIN/B 0.39405f
C716 RDA/R1_6 RIN/B 0.39179f
C717 RDA/R2_5 RIN/B 0.39753f
C718 RDA/R1_4 RIN/B 0.3946f
C719 RDA/R2_3 RIN/B 0.39767f
C720 xq0/X RIN/B 2.6978f
C721 RDA/R1_2 RIN/B 0.39372f
C722 RDA/R1_0 RIN/B 0.40129f $ **FLOATING
C723 xq2/A RIN/B 1.46187f
C724 dff6/D RIN/B 2.59894f
C725 xq3/VPB RIN/B 13.61485f
C726 dff6/a_381_47# RIN/B 0.0164f
C727 dff6/a_891_413# RIN/B 0.16063f
C728 dff6/a_1062_300# RIN/B 0.53288f
C729 dff6/a_475_413# RIN/B 0.13736f
C730 dff6/a_634_183# RIN/B 0.15128f
C731 dff6/a_193_47# RIN/B 0.27239f
C732 dff6/a_27_47# RIN/B 0.49969f
C733 dff5/D RIN/B 4.42457f
C734 dff5/a_381_47# RIN/B 0.0164f
C735 dff5/a_891_413# RIN/B 0.16096f
C736 dff5/a_1062_300# RIN/B 0.5326f
C737 dff5/a_475_413# RIN/B 0.13733f
C738 dff5/a_634_183# RIN/B 0.15031f
C739 dff5/a_193_47# RIN/B 0.27187f
C740 dff5/a_27_47# RIN/B 0.4981f
C741 dff4/D RIN/B 3.14699f
C742 dff4/a_381_47# RIN/B 0.0164f
C743 dff4/a_891_413# RIN/B 0.16094f
C744 dff4/a_1062_300# RIN/B 0.53148f
C745 dff4/a_475_413# RIN/B 0.13733f
C746 dff4/a_634_183# RIN/B 0.15031f
C747 dff4/a_193_47# RIN/B 0.27176f
C748 dff4/a_27_47# RIN/B 0.49809f
C749 xq6/X RIN/B 3.75768f
C750 xq6/a_35_297# RIN/B 0.25274f
C751 dff3/D RIN/B 2.69764f
C752 dff3/a_381_47# RIN/B 0.0164f
C753 dff3/a_891_413# RIN/B 0.16094f
C754 dff3/a_1062_300# RIN/B 0.53243f
C755 dff3/a_475_413# RIN/B 0.13775f
C756 dff3/a_634_183# RIN/B 0.15014f
C757 dff3/a_193_47# RIN/B 0.27154f
C758 dff3/a_27_47# RIN/B 0.49817f
C759 xq5/X RIN/B 1.727f
C760 xq5/a_35_297# RIN/B 0.25274f
C761 dff2/D RIN/B 2.56453f
C762 dff2/a_381_47# RIN/B 0.0164f
C763 dff2/a_891_413# RIN/B 0.16098f
C764 dff2/a_1062_300# RIN/B 0.53165f
C765 dff2/a_475_413# RIN/B 0.13757f
C766 dff2/a_634_183# RIN/B 0.15019f
C767 dff2/a_193_47# RIN/B 0.27266f
C768 dff2/a_27_47# RIN/B 0.49836f
C769 xq1/VPB RIN/B 14.61262f
C770 xq4/X RIN/B 1.59104f
C771 xq4/a_35_297# RIN/B 0.25274f
.ends

.subckt sky130_fd_sc_hd__inv_1 VPB VNB VGND VPWR A Y
X0 Y A VGND VNB sky130_fd_pr__nfet_01v8 ad=0.169 pd=1.82 as=0.169 ps=1.82 w=0.65 l=0.15
X1 Y A VPWR VPB sky130_fd_pr__pfet_01v8_hvt ad=0.26 pd=2.52 as=0.26 ps=2.52 w=1 l=0.15
C0 Y VPB 0.01774f
C1 Y VPWR 0.12758f
C2 Y A 0.0476f
C3 VGND Y 0.09984f
C4 VPB VPWR 0.05448f
C5 VPB A 0.04506f
C6 VPWR A 0.03703f
C7 VGND VPWR 0.03382f
C8 VGND A 0.04004f
C9 VGND VNB 0.25113f
C10 Y VNB 0.0961f
C11 VPWR VNB 0.21892f
C12 A VNB 0.16664f
C13 VPB VNB 0.33898f
.ends

.subckt tt_um_arcadia1_vco_adc clk ena rst_n ua[0] ua[1] ua[2] ua[3] ua[4] ua[5] ua[6]
+ ua[7] ui_in[0] ui_in[1] ui_in[2] ui_in[3] ui_in[4] ui_in[5] ui_in[6] ui_in[7] uio_in[0]
+ uio_in[1] uio_in[2] uio_in[3] uio_in[4] uio_in[5] uio_in[6] uio_in[7] uio_out[0]
+ uio_out[1] uio_out[2] uio_out[3] uio_out[4] uio_out[5] uio_out[6] uio_out[7] uo_out[0]
+ uo_out[1] uo_out[2] uo_out[3] uo_out[4] uo_out[5] uo_out[6] uo_out[7] VGND VDPWR
XRT RT/R1_5 RT/R1_3 RT/R1_3 RT/R1_1 RT/R1_1 VGND RT/R2_7 RT/R2_6 RT/R2_6 RT/R2_4 RT/R2_4
+ RT/R2_2 RT/R2_2 VDPWR RT/R1_7 RT/R1_7 RT/R1_5 sky130_fd_pr__res_xhigh_po_0p35_4MFQX6
XRARR VGND RARR/R1_3 VGND RARR/R1_1 VGND VGND VGND RARR/R2_4 RARR/R2_3 RARR/R2_3 RARR/R2_4
+ VGND VGND sky130_fd_pr__res_xhigh_po_0p35_9LMN9P
XRB RB/R1_3 RB/R1_3 RB/R1_1 RB/R1_1 VGND RB/R2_3 RB/R2_2 RB/R2_2 VDPWR sky130_fd_pr__res_xhigh_po_0p35_V6BCNG
XhalfN irst/Y halfN/mon/A halfN/xq3/X halfN/CM1/C1 RARR/R1_1 RB/R2_3 VDPWR halfN/a_586_39570#
+ uio_out[5] RT/R2_7 uio_out[7] VGND uio_out[0] VDPWR halfN/xq4/X VDPWR clk halfN/RDA/R1_18
+ VDPWR halfN/xq6/X halfN/CM1/C2 clk halfN/dff5/D uio_out[2] uio_out[6] uio_out[1]
+ uio_out[3] VDPWR halfN/RDA/R1_22 halfN/xq5/X ua[1] halfN/dff4/D uio_out[4] VGND
+ VDPWR vco_adc_half
XhalfP irst/Y halfP/mon/A halfP/xq3/X halfP/CM1/C1 RARR/R1_3 RB/R2_3 VDPWR halfP/a_586_39570#
+ uo_out[2] RT/R2_7 uo_out[0] VGND uo_out[7] VDPWR halfP/xq4/X VDPWR clk halfP/RDA/R1_18
+ VDPWR halfP/xq6/X halfP/CM1/C2 clk halfP/dff5/D uo_out[5] uo_out[1] uo_out[6] uo_out[4]
+ VDPWR halfP/RDA/R1_22 halfP/xq5/X ua[0] halfP/dff4/D uo_out[3] VGND VDPWR vco_adc_half
Xirst VDPWR VGND VGND VDPWR rst_n irst/Y sky130_fd_sc_hd__inv_1
XRBT RBT/R1_5 RBT/R1_3 RBT/R1_3 RBT/R1_1 RBT/R1_1 VGND VGND RBT/R2_6 RBT/R2_6 RBT/R2_4
+ RBT/R2_4 RBT/R2_2 RBT/R2_2 RT/R2_7 RBT/R1_7 RBT/R1_7 RBT/R1_5 sky130_fd_pr__res_xhigh_po_0p35_4MFQX6
X0 VGND RB/R2_3 RB/R2_3 VGND sky130_fd_pr__nfet_01v8 ad=0.66 pd=4.66 as=0.37 ps=2.37 w=2 l=2
X1 VGND RT/R2_7 VGND VGND sky130_fd_pr__nfet_01v8 ad=1.65 pd=10.66 as=52.25745 ps=493.85999 w=5 l=10
X2 RB/R2_3 RB/R2_3 VGND VGND sky130_fd_pr__nfet_01v8 ad=0.37 pd=2.37 as=0.66 ps=4.66 w=2 l=2
X3 VGND RT/R2_7 VGND VGND sky130_fd_pr__nfet_01v8 ad=0.925 pd=5.37 as=0 ps=0 w=5 l=10
C0 halfP/CM1/C2 RBT/R1_3 0.01305f
C1 halfP/mon/A halfN/mon/A 0.10005f
C2 halfN/xq5/X VDPWR 0.06883f
C3 uo_out[2] VDPWR 0.02713f
C4 rst_n halfP/xq0/X 0.01872f
C5 rst_n RB/R2_3 0.02658f
C6 ua[1] RB/R2_3 0.4699f
C7 uo_out[4] clk 0.04242f
C8 uio_in[0] uio_in[1] 0.03102f
C9 halfN/xq3/X VDPWR 0.03075f
C10 VDPWR RT/R2_4 0.01635f
C11 ui_in[1] ui_in[0] 0.03102f
C12 ui_in[7] uio_in[0] 0.03102f
C13 VDPWR uio_out[7] 0.73129f
C14 ua[0] VDPWR 2.98252f
C15 RT/R2_6 VDPWR 0.01632f
C16 rst_n RT/R2_7 0.31855f
C17 rst_n halfP/xq2/X 0.03421f
C18 ua[1] RT/R2_7 0.39686f
C19 halfP/CM1/C2 RT/R1_1 0.01305f
C20 rst_n ui_in[0] 0.03102f
C21 halfN/RDA/R1_22 VDPWR 0.0106f
C22 uio_out[2] VDPWR 0.15598f
C23 halfP/xq3/X rst_n 0.05345f
C24 RB/R2_3 VDPWR 0.08888f
C25 RBT/R2_6 VDPWR 0.01631f
C26 ui_in[1] ui_in[2] 0.03102f
C27 irst/Y rst_n 0.18658f
C28 halfP/CM1/C2 halfN/CM1/C2 0.50085f
C29 irst/Y ua[1] 0.65176f
C30 RBT/R1_5 rst_n 0.04338f
C31 clk uo_out[7] 0.01445f
C32 RBT/R1_5 ua[1] 0.01085f
C33 halfP/CM1/C2 rst_n 1.08429f
C34 RBT/R2_4 VDPWR 0.01631f
C35 halfN/CM1/C1 ua[1] 0.02078f
C36 halfP/CM1/C2 ua[1] 0.01272f
C37 RBT/R2_2 VDPWR 0.01631f
C38 RT/R2_7 VDPWR 0.89892f
C39 halfP/xq1/X rst_n 0.02603f
C40 uio_in[5] uio_in[6] 0.03102f
C41 rst_n RT/R1_5 0.04338f
C42 rst_n RBT/R1_1 0.04671f
C43 RARR/R1_3 RARR/R1_1 0.0619f
C44 halfP/CM1/C2 RT/R1_7 0.01305f
C45 halfP/CM1/C2 RBT/R1_7 0.01305f
C46 RT/R1_5 ua[1] 0.01085f
C47 ua[1] RBT/R1_1 0.01085f
C48 uio_out[5] VDPWR 0.14592f
C49 VDPWR halfN/xq4/X 0.03961f
C50 RT/R2_7 RT/R2_4 0.03749f
C51 RB/R1_1 ua[1] 0.05418f
C52 VDPWR halfP/dff5/D 0.01225f
C53 uio_in[4] uio_in[3] 0.03102f
C54 RB/R2_2 VDPWR 0.01663f
C55 RT/R1_7 RBT/R1_1 0.04565f
C56 irst/Y VDPWR 0.24084f
C57 RT/R2_6 RT/R2_7 0.05628f
C58 halfN/xq6/X VDPWR 0.3021f
C59 RARR/R2_4 RARR/R2_3 0.12578f
C60 halfP/CM1/C2 RT/R1_3 0.01305f
C61 rst_n RBT/R1_3 0.04338f
C62 rst_n halfP/xq5/X 0.17644f
C63 clk ena 0.03102f
C64 RB/R2_3 RT/R2_7 1.74637f
C65 ua[1] RBT/R1_3 0.01085f
C66 ua[1] RB/R1_3 0.05418f
C67 rst_n halfP/CM1/C1 0.03883f
C68 ua[1] halfP/CM1/C1 0.02055f
C69 uo_out[5] clk 0.0201f
C70 uio_out[4] VDPWR 0.14402f
C71 rst_n clk 0.19099f
C72 RT/R2_2 VDPWR 0.01663f
C73 uio_in[7] uio_in[6] 0.03102f
C74 RB/R2_2 RB/R2_3 0.01866f
C75 irst/Y RB/R2_3 1.2307f
C76 ui_in[4] ui_in[3] 0.03102f
C77 ui_in[5] ui_in[6] 0.03102f
C78 uo_out[6] clk 0.12527f
C79 rst_n RT/R1_1 0.04969f
C80 ua[1] RT/R1_1 0.01085f
C81 halfN/xq1/X VDPWR 0.01713f
C82 clk uo_out[3] 0.01571f
C83 irst/Y RT/R2_7 0.95269f
C84 clk VDPWR 0.81983f
C85 uio_in[7] uo_out[0] 0.03274f
C86 uo_out[1] clk 0.02749f
C87 ua[1] halfN/CM1/C2 0.82425f
C88 uo_out[2] clk 0.01288f
C89 rst_n halfP/xq6/X 0.89938f
C90 uo_out[7] uio_out[0] 0.51433f
C91 halfN/dff5/D VDPWR 0.01225f
C92 rst_n ua[1] 3.22582f
C93 uio_out[6] VDPWR 0.16702f
C94 clk uio_out[7] -0.01056f
C95 uio_in[3] uio_in[2] 0.03102f
C96 halfN/CM1/C2 RARR/R1_1 0.01462f
C97 clk uio_out[0] 0.01445f
C98 ui_in[7] ui_in[6] 0.03102f
C99 RT/R1_7 rst_n 0.04671f
C100 ui_in[5] ui_in[4] 0.03102f
C101 rst_n RBT/R1_7 0.04853f
C102 uo_out[6] uio_out[1] 0.02244f
C103 RT/R1_7 ua[1] 0.01085f
C104 ua[1] RBT/R1_7 0.01085f
C105 halfP/CM1/C2 RARR/R1_3 0.01191f
C106 uio_in[4] uio_in[5] 0.03102f
C107 RT/R2_2 RT/R2_7 0.03527f
C108 uio_in[1] uio_in[2] 0.03102f
C109 VDPWR halfP/RDA/R1_22 0.0106f
C110 halfP/CM1/C2 RBT/R1_5 0.01305f
C111 rst_n RT/R1_3 0.04422f
C112 uio_out[1] VDPWR 0.25349f
C113 halfN/xq2/X VDPWR 0.02018f
C114 rst_n VDPWR 0.41505f
C115 ua[1] RT/R1_3 0.01085f
C116 rst_n halfP/xq4/X 0.08343f
C117 halfP/CM1/C2 RT/R1_5 0.01305f
C118 halfP/CM1/C2 RBT/R1_1 0.01305f
C119 ua[1] VDPWR 1.51738f
C120 clk uo_out[0] 0.10094f
C121 ui_in[2] ui_in[3] 0.03102f
C122 uo_out[6] VDPWR 0.05092f
C123 ua[0] rst_n 1.20019f
C124 halfN/xq0/X VDPWR 0.01153f
C125 ua[0] ua[1] 0.03671f
C126 uio_out[3] VDPWR 0.17441f
C127 VDPWR uo_out[3] 0.02524f
C128 ua[2] VGND 0.14723f
C129 ua[3] VGND 0.14723f
C130 ua[4] VGND 0.14723f
C131 ua[5] VGND 0.14723f
C132 ua[6] VGND 0.14723f
C133 ua[7] VGND 0.14723f
C134 ena VGND 0.07059f
C135 ui_in[0] VGND 0.04301f
C136 ui_in[1] VGND 0.04301f
C137 ui_in[2] VGND 0.04307f
C138 ui_in[3] VGND 0.04307f
C139 ui_in[4] VGND 0.04307f
C140 ui_in[5] VGND 0.04329f
C141 ui_in[6] VGND 0.04301f
C142 ui_in[7] VGND 0.04301f
C143 uio_in[0] VGND 0.04301f
C144 uio_in[1] VGND 0.04301f
C145 uio_in[2] VGND 0.04301f
C146 uio_in[3] VGND 0.04301f
C147 uio_in[4] VGND 0.04301f
C148 uio_in[5] VGND 0.04301f
C149 uio_in[6] VGND 0.04301f
C150 uio_in[7] VGND 0.04301f
C151 RBT/R1_7 VGND 0.60865f
C152 RBT/R2_6 VGND 0.37658f
C153 RBT/R1_5 VGND 0.38618f
C154 RBT/R2_4 VGND 0.37059f
C155 RBT/R1_3 VGND 0.38618f
C156 RBT/R2_2 VGND 0.36973f
C157 RBT/R1_1 VGND 0.55583f
C158 irst/Y VGND 6.78188f
C159 rst_n VGND 1.13124f
C160 halfP/a_2306_26380# VGND 1.54242f $ **FLOATING
C161 halfP/a_3032_27474# VGND 1.1053f $ **FLOATING
C162 halfP/a_1066_39096# VGND 5.05355f $ **FLOATING
C163 halfP/a_586_39570# VGND 2.359f
C164 halfP/xq3/X VGND 1.47992f
C165 halfP/xq3/a_35_297# VGND 0.25457f
C166 uo_out[2] VGND 1.23408f
C167 halfP/dff1/D VGND 2.34494f
C168 halfP/dff1/a_381_47# VGND 0.0164f
C169 halfP/dff1/a_891_413# VGND 0.16089f
C170 halfP/dff1/a_1062_300# VGND 0.52966f
C171 halfP/dff1/a_475_413# VGND 0.13718f
C172 halfP/dff1/a_634_183# VGND 0.15021f
C173 halfP/dff1/a_193_47# VGND 0.27118f
C174 halfP/dff1/a_27_47# VGND 0.4683f
C175 halfP/xq2/a_35_297# VGND 0.25457f
C176 uo_out[6] VGND 1.53461f
C177 halfP/mon/A VGND 3.27388f
C178 clk VGND 15.30977f
C179 halfP/dff0/a_381_47# VGND 0.0164f
C180 halfP/dff0/a_891_413# VGND 0.16089f
C181 halfP/dff0/a_1062_300# VGND 0.52966f
C182 halfP/dff0/a_475_413# VGND 0.13718f
C183 halfP/dff0/a_634_183# VGND 0.15021f
C184 halfP/dff0/a_193_47# VGND 0.27134f
C185 halfP/dff0/a_27_47# VGND 0.46838f
C186 halfP/xq6/B VGND 0.19993f
C187 uo_out[0] VGND 2.18805f
C188 halfP/dq6/a_381_47# VGND 0.01537f
C189 halfP/dq6/a_891_413# VGND 0.16105f
C190 halfP/dq6/a_1059_315# VGND 0.24885f
C191 halfP/dq6/a_466_413# VGND 0.1332f
C192 halfP/dq6/a_634_159# VGND 0.14231f
C193 halfP/dq6/a_193_47# VGND 0.28426f
C194 halfP/dq6/a_27_47# VGND 0.44951f
C195 halfP/xq1/a_35_297# VGND 0.25457f
C196 halfP/xq5/B VGND 0.18682f
C197 uo_out[4] VGND 1.43409f
C198 halfP/dq5/a_381_47# VGND 0.01537f
C199 halfP/dq5/a_891_413# VGND 0.16105f
C200 halfP/dq5/a_1059_315# VGND 0.24885f
C201 halfP/dq5/a_466_413# VGND 0.1332f
C202 halfP/dq5/a_634_159# VGND 0.14231f
C203 halfP/dq5/a_193_47# VGND 0.28426f
C204 halfP/dq5/a_27_47# VGND 0.44951f
C205 halfP/xq0/a_35_297# VGND 0.25457f
C206 halfP/xq4/B VGND 0.18682f
C207 uo_out[1] VGND 1.03842f
C208 halfP/dq4/a_381_47# VGND 0.01537f
C209 halfP/dq4/a_891_413# VGND 0.16105f
C210 halfP/dq4/a_1059_315# VGND 0.24885f
C211 halfP/dq4/a_466_413# VGND 0.1332f
C212 halfP/dq4/a_634_159# VGND 0.14231f
C213 halfP/dq4/a_193_47# VGND 0.28426f
C214 halfP/dq4/a_27_47# VGND 0.44951f
C215 halfP/xq3/B VGND 0.18682f
C216 uo_out[5] VGND 1.19459f
C217 halfP/dq3/a_381_47# VGND 0.01537f
C218 halfP/dq3/a_891_413# VGND 0.16105f
C219 halfP/dq3/a_1059_315# VGND 0.24885f
C220 halfP/dq3/a_466_413# VGND 0.1332f
C221 halfP/dq3/a_634_159# VGND 0.14231f
C222 halfP/dq3/a_193_47# VGND 0.28426f
C223 halfP/dq3/a_27_47# VGND 0.44951f
C224 halfP/xq2/B VGND 0.18682f
C225 halfP/dq2/a_381_47# VGND 0.01537f
C226 halfP/dq2/a_891_413# VGND 0.16105f
C227 halfP/dq2/a_1059_315# VGND 0.24885f
C228 halfP/dq2/a_466_413# VGND 0.1332f
C229 halfP/dq2/a_634_159# VGND 0.14231f
C230 halfP/dq2/a_193_47# VGND 0.28426f
C231 halfP/dq2/a_27_47# VGND 0.44951f
C232 halfP/xq0/B VGND 0.20094f
C233 halfP/dq0/a_381_47# VGND 0.01537f
C234 halfP/dq0/a_891_413# VGND 0.16105f
C235 halfP/dq0/a_1059_315# VGND 0.24885f
C236 halfP/dq0/a_466_413# VGND 0.1332f
C237 halfP/dq0/a_634_159# VGND 0.14231f
C238 halfP/dq0/a_193_47# VGND 0.28426f
C239 halfP/dq0/a_27_47# VGND 0.44951f
C240 halfP/xq1/B VGND 0.18682f
C241 halfP/dq1/a_381_47# VGND 0.01537f
C242 halfP/dq1/a_891_413# VGND 0.16105f
C243 halfP/dq1/a_1059_315# VGND 0.24885f
C244 halfP/dq1/a_466_413# VGND 0.1332f
C245 halfP/dq1/a_634_159# VGND 0.14231f
C246 halfP/dq1/a_193_47# VGND 0.28426f
C247 halfP/dq1/a_27_47# VGND 0.44951f
C248 halfP/CM1/C1 VGND 13.96271f
C249 halfP/CM1/C2 VGND 28.19343f
C250 uo_out[7] VGND 0.06158f
C251 halfP/mon/a_27_47# VGND 0.46147f
C252 ua[0] VGND 9.68177f
C253 halfP/RIN/R1_1 VGND 0.81996f
C254 halfP/RDA/R1_43 VGND 0.40066f $ **FLOATING
C255 halfP/RDA/R1_42 VGND 0.39677f
C256 halfP/RDA/R2_41 VGND 0.39677f
C257 halfP/RDA/R1_40 VGND 0.39677f
C258 halfP/RDA/R2_39 VGND 0.39666f
C259 halfP/RDA/R1_38 VGND 0.39677f
C260 halfP/RDA/R1_36 VGND 0.39677f
C261 halfP/RDA/R2_35 VGND 0.39677f
C262 halfP/RDA/R1_34 VGND 0.39677f
C263 halfP/RDA/R2_33 VGND 0.39677f
C264 halfP/RDA/R1_32 VGND 0.39677f
C265 halfP/RDA/R1_30 VGND 0.39672f
C266 halfP/RDA/R2_29 VGND 0.39677f
C267 halfP/RDA/R1_28 VGND 0.39677f
C268 halfP/RDA/R2_27 VGND 0.39677f
C269 halfP/RDA/R1_26 VGND 0.39677f
C270 halfP/RDA/R1_24 VGND 0.39677f
C271 halfP/RDA/R2_23 VGND 0.39677f
C272 halfP/RDA/R1_22 VGND 0.39689f
C273 halfP/RDA/R2_21 VGND 0.39677f
C274 halfP/RDA/R1_20 VGND 0.39677f
C275 halfP/RDA/R1_18 VGND 0.41219f
C276 halfP/RDA/R2_17 VGND 0.39677f
C277 halfP/RDA/R1_16 VGND 0.39334f
C278 halfP/RDA/R2_15 VGND 0.39677f
C279 halfP/xq2/X VGND 1.29357f
C280 halfP/RDA/R1_14 VGND 0.3916f
C281 halfP/RDA/R1_12 VGND 0.39358f
C282 halfP/RDA/R2_11 VGND 0.39677f
C283 halfP/RDA/R1_9 VGND 0.39203f
C284 halfP/RDA/R2_9 VGND 0.39677f
C285 halfP/xq1/X VGND 1.28658f
C286 halfP/RDA/R1_8 VGND 0.39286f
C287 halfP/RDA/R1_6 VGND 0.39047f
C288 halfP/RDA/R2_5 VGND 0.39666f
C289 halfP/RDA/R1_4 VGND 0.39328f
C290 halfP/RDA/R2_3 VGND 0.39677f
C291 halfP/xq0/X VGND 2.39763f
C292 halfP/RDA/R1_2 VGND 0.39251f
C293 halfP/RDA/R1_0 VGND 0.40066f $ **FLOATING
C294 uo_out[3] VGND 1.02521f
C295 halfP/dff6/D VGND 2.47015f
C296 halfP/dff6/a_381_47# VGND 0.0164f
C297 halfP/dff6/a_891_413# VGND 0.16089f
C298 halfP/dff6/a_1062_300# VGND 0.52966f
C299 halfP/dff6/a_475_413# VGND 0.13718f
C300 halfP/dff6/a_634_183# VGND 0.15021f
C301 halfP/dff6/a_193_47# VGND 0.27118f
C302 halfP/dff6/a_27_47# VGND 0.4683f
C303 halfP/dff5/D VGND 4.07731f
C304 halfP/dff5/a_381_47# VGND 0.0164f
C305 halfP/dff5/a_891_413# VGND 0.16089f
C306 halfP/dff5/a_1062_300# VGND 0.52993f
C307 halfP/dff5/a_475_413# VGND 0.13718f
C308 halfP/dff5/a_634_183# VGND 0.15021f
C309 halfP/dff5/a_193_47# VGND 0.27118f
C310 halfP/dff5/a_27_47# VGND 0.4683f
C311 halfP/dff4/D VGND 2.82023f
C312 halfP/dff4/a_381_47# VGND 0.0164f
C313 halfP/dff4/a_891_413# VGND 0.16089f
C314 halfP/dff4/a_1062_300# VGND 0.52966f
C315 halfP/dff4/a_475_413# VGND 0.13718f
C316 halfP/dff4/a_634_183# VGND 0.15021f
C317 halfP/dff4/a_193_47# VGND 0.27119f
C318 halfP/dff4/a_27_47# VGND 0.4683f
C319 halfP/xq6/X VGND 3.691f
C320 halfP/xq6/a_35_297# VGND 0.25457f
C321 halfP/dff3/D VGND 2.47213f
C322 halfP/dff3/a_381_47# VGND 0.0164f
C323 halfP/dff3/a_891_413# VGND 0.16089f
C324 halfP/dff3/a_1062_300# VGND 0.52966f
C325 halfP/dff3/a_475_413# VGND 0.13718f
C326 halfP/dff3/a_634_183# VGND 0.15021f
C327 halfP/dff3/a_193_47# VGND 0.27118f
C328 halfP/dff3/a_27_47# VGND 0.4683f
C329 halfP/xq5/X VGND 1.61333f
C330 halfP/xq5/a_35_297# VGND 0.25457f
C331 halfP/dff2/D VGND 2.33687f
C332 halfP/dff2/a_381_47# VGND 0.0164f
C333 halfP/dff2/a_891_413# VGND 0.16089f
C334 halfP/dff2/a_1062_300# VGND 0.52966f
C335 halfP/dff2/a_475_413# VGND 0.13718f
C336 halfP/dff2/a_634_183# VGND 0.15021f
C337 halfP/dff2/a_193_47# VGND 0.27123f
C338 halfP/dff2/a_27_47# VGND 0.46832f
C339 halfP/xq4/X VGND 1.4964f
C340 halfP/xq4/a_35_297# VGND 0.25457f
C341 halfN/a_2306_26380# VGND 1.54242f $ **FLOATING
C342 RT/R2_7 VGND 17.37497f
C343 halfN/a_3032_27474# VGND 1.1053f $ **FLOATING
C344 RARR/R1_1 VGND 0.94245f
C345 halfN/a_1066_39096# VGND 5.05355f $ **FLOATING
C346 halfN/a_586_39570# VGND 2.359f
C347 halfN/xq3/X VGND 1.4817f
C348 halfN/xq3/a_35_297# VGND 0.25457f
C349 uio_out[5] VGND 1.22202f
C350 halfN/dff1/D VGND 2.34494f
C351 halfN/dff1/a_381_47# VGND 0.0164f
C352 halfN/dff1/a_891_413# VGND 0.16089f
C353 halfN/dff1/a_1062_300# VGND 0.52966f
C354 halfN/dff1/a_475_413# VGND 0.13718f
C355 halfN/dff1/a_634_183# VGND 0.15021f
C356 halfN/dff1/a_193_47# VGND 0.27118f
C357 halfN/dff1/a_27_47# VGND 0.4683f
C358 halfN/xq2/a_35_297# VGND 0.25457f
C359 uio_out[1] VGND 1.522f
C360 halfN/mon/A VGND 3.27388f
C361 halfN/dff0/a_381_47# VGND 0.0164f
C362 halfN/dff0/a_891_413# VGND 0.16089f
C363 halfN/dff0/a_1062_300# VGND 0.52966f
C364 halfN/dff0/a_475_413# VGND 0.13718f
C365 halfN/dff0/a_634_183# VGND 0.15021f
C366 halfN/dff0/a_193_47# VGND 0.27134f
C367 halfN/dff0/a_27_47# VGND 0.46838f
C368 halfN/xq6/B VGND 0.19993f
C369 uio_out[7] VGND 1.99507f
C370 halfN/dq6/a_381_47# VGND 0.01537f
C371 halfN/dq6/a_891_413# VGND 0.16105f
C372 halfN/dq6/a_1059_315# VGND 0.24885f
C373 halfN/dq6/a_466_413# VGND 0.1332f
C374 halfN/dq6/a_634_159# VGND 0.14231f
C375 halfN/dq6/a_193_47# VGND 0.28426f
C376 halfN/dq6/a_27_47# VGND 0.44951f
C377 halfN/xq1/a_35_297# VGND 0.25457f
C378 halfN/xq5/B VGND 0.18682f
C379 uio_out[3] VGND 1.43409f
C380 halfN/dq5/a_381_47# VGND 0.01537f
C381 halfN/dq5/a_891_413# VGND 0.16105f
C382 halfN/dq5/a_1059_315# VGND 0.24885f
C383 halfN/dq5/a_466_413# VGND 0.1332f
C384 halfN/dq5/a_634_159# VGND 0.14231f
C385 halfN/dq5/a_193_47# VGND 0.28426f
C386 halfN/dq5/a_27_47# VGND 0.44951f
C387 halfN/xq0/a_35_297# VGND 0.25457f
C388 halfN/xq4/B VGND 0.18682f
C389 uio_out[6] VGND 1.02942f
C390 halfN/dq4/a_381_47# VGND 0.01537f
C391 halfN/dq4/a_891_413# VGND 0.16105f
C392 halfN/dq4/a_1059_315# VGND 0.24885f
C393 halfN/dq4/a_466_413# VGND 0.1332f
C394 halfN/dq4/a_634_159# VGND 0.14231f
C395 halfN/dq4/a_193_47# VGND 0.28426f
C396 halfN/dq4/a_27_47# VGND 0.44951f
C397 halfN/xq3/B VGND 0.18682f
C398 uio_out[2] VGND 1.19459f
C399 halfN/dq3/a_381_47# VGND 0.01537f
C400 halfN/dq3/a_891_413# VGND 0.16105f
C401 halfN/dq3/a_1059_315# VGND 0.24885f
C402 halfN/dq3/a_466_413# VGND 0.1332f
C403 halfN/dq3/a_634_159# VGND 0.14231f
C404 halfN/dq3/a_193_47# VGND 0.28426f
C405 halfN/dq3/a_27_47# VGND 0.44951f
C406 halfN/xq2/B VGND 0.18682f
C407 halfN/dq2/a_381_47# VGND 0.01537f
C408 halfN/dq2/a_891_413# VGND 0.16105f
C409 halfN/dq2/a_1059_315# VGND 0.24885f
C410 halfN/dq2/a_466_413# VGND 0.1332f
C411 halfN/dq2/a_634_159# VGND 0.14231f
C412 halfN/dq2/a_193_47# VGND 0.28426f
C413 halfN/dq2/a_27_47# VGND 0.44951f
C414 halfN/xq0/B VGND 0.20094f
C415 halfN/dq0/a_381_47# VGND 0.01537f
C416 halfN/dq0/a_891_413# VGND 0.16105f
C417 halfN/dq0/a_1059_315# VGND 0.24885f
C418 halfN/dq0/a_466_413# VGND 0.1332f
C419 halfN/dq0/a_634_159# VGND 0.14231f
C420 halfN/dq0/a_193_47# VGND 0.28426f
C421 halfN/dq0/a_27_47# VGND 0.44951f
C422 halfN/xq1/B VGND 0.18682f
C423 halfN/dq1/a_381_47# VGND 0.01537f
C424 halfN/dq1/a_891_413# VGND 0.16105f
C425 halfN/dq1/a_1059_315# VGND 0.24885f
C426 halfN/dq1/a_466_413# VGND 0.1332f
C427 halfN/dq1/a_634_159# VGND 0.14231f
C428 halfN/dq1/a_193_47# VGND 0.28426f
C429 halfN/dq1/a_27_47# VGND 0.44951f
C430 halfN/CM1/C1 VGND 13.94687f
C431 halfN/CM1/C2 VGND 28.11435f
C432 uio_out[0] VGND 0.06158f
C433 halfN/mon/a_27_47# VGND 0.46147f
C434 ua[1] VGND 12.28039f
C435 halfN/RIN/R1_1 VGND 0.81996f
C436 halfN/RDA/R1_43 VGND 0.40066f $ **FLOATING
C437 halfN/RDA/R1_42 VGND 0.39677f
C438 halfN/RDA/R2_41 VGND 0.39677f
C439 halfN/RDA/R1_40 VGND 0.39677f
C440 halfN/RDA/R2_39 VGND 0.39666f
C441 halfN/RDA/R1_38 VGND 0.39677f
C442 halfN/RDA/R1_36 VGND 0.39677f
C443 halfN/RDA/R2_35 VGND 0.39677f
C444 halfN/RDA/R1_34 VGND 0.39677f
C445 halfN/RDA/R2_33 VGND 0.39677f
C446 halfN/RDA/R1_32 VGND 0.39677f
C447 halfN/RDA/R1_30 VGND 0.39672f
C448 halfN/RDA/R2_29 VGND 0.39677f
C449 halfN/RDA/R1_28 VGND 0.39677f
C450 halfN/RDA/R2_27 VGND 0.39677f
C451 halfN/RDA/R1_26 VGND 0.39677f
C452 halfN/RDA/R1_24 VGND 0.39677f
C453 halfN/RDA/R2_23 VGND 0.39677f
C454 halfN/RDA/R1_22 VGND 0.39689f
C455 halfN/RDA/R2_21 VGND 0.39677f
C456 halfN/RDA/R1_20 VGND 0.39677f
C457 halfN/RDA/R1_18 VGND 0.41219f
C458 halfN/RDA/R2_17 VGND 0.39677f
C459 halfN/RDA/R1_16 VGND 0.39334f
C460 halfN/RDA/R2_15 VGND 0.39677f
C461 halfN/xq2/X VGND 1.29377f
C462 halfN/RDA/R1_14 VGND 0.3916f
C463 halfN/RDA/R1_12 VGND 0.39358f
C464 halfN/RDA/R2_11 VGND 0.39677f
C465 halfN/RDA/R1_9 VGND 0.39203f
C466 halfN/RDA/R2_9 VGND 0.39677f
C467 halfN/xq1/X VGND 1.28658f
C468 halfN/RDA/R1_8 VGND 0.39286f
C469 halfN/RDA/R1_6 VGND 0.39047f
C470 halfN/RDA/R2_5 VGND 0.39666f
C471 halfN/RDA/R1_4 VGND 0.39328f
C472 halfN/RDA/R2_3 VGND 0.39677f
C473 halfN/xq0/X VGND 2.39763f
C474 halfN/RDA/R1_2 VGND 0.39251f
C475 halfN/RDA/R1_0 VGND 0.40066f $ **FLOATING
C476 uio_out[4] VGND 1.01315f
C477 halfN/dff6/D VGND 2.47015f
C478 VDPWR VGND 0.38053p
C479 halfN/dff6/a_381_47# VGND 0.0164f
C480 halfN/dff6/a_891_413# VGND 0.16089f
C481 halfN/dff6/a_1062_300# VGND 0.52966f
C482 halfN/dff6/a_475_413# VGND 0.13718f
C483 halfN/dff6/a_634_183# VGND 0.15021f
C484 halfN/dff6/a_193_47# VGND 0.27118f
C485 halfN/dff6/a_27_47# VGND 0.4683f
C486 halfN/dff5/D VGND 4.07731f
C487 halfN/dff5/a_381_47# VGND 0.0164f
C488 halfN/dff5/a_891_413# VGND 0.16089f
C489 halfN/dff5/a_1062_300# VGND 0.52986f
C490 halfN/dff5/a_475_413# VGND 0.13718f
C491 halfN/dff5/a_634_183# VGND 0.15021f
C492 halfN/dff5/a_193_47# VGND 0.27118f
C493 halfN/dff5/a_27_47# VGND 0.4683f
C494 halfN/dff4/D VGND 2.82023f
C495 halfN/dff4/a_381_47# VGND 0.0164f
C496 halfN/dff4/a_891_413# VGND 0.16089f
C497 halfN/dff4/a_1062_300# VGND 0.52966f
C498 halfN/dff4/a_475_413# VGND 0.13718f
C499 halfN/dff4/a_634_183# VGND 0.15021f
C500 halfN/dff4/a_193_47# VGND 0.27119f
C501 halfN/dff4/a_27_47# VGND 0.4683f
C502 halfN/xq6/X VGND 3.7469f
C503 halfN/xq6/a_35_297# VGND 0.25457f
C504 halfN/dff3/D VGND 2.47213f
C505 halfN/dff3/a_381_47# VGND 0.0164f
C506 halfN/dff3/a_891_413# VGND 0.16089f
C507 halfN/dff3/a_1062_300# VGND 0.52966f
C508 halfN/dff3/a_475_413# VGND 0.13718f
C509 halfN/dff3/a_634_183# VGND 0.15021f
C510 halfN/dff3/a_193_47# VGND 0.27118f
C511 halfN/dff3/a_27_47# VGND 0.4683f
C512 halfN/xq5/X VGND 1.61716f
C513 halfN/xq5/a_35_297# VGND 0.25457f
C514 halfN/dff2/D VGND 2.33687f
C515 halfN/dff2/a_381_47# VGND 0.0164f
C516 halfN/dff2/a_891_413# VGND 0.16089f
C517 halfN/dff2/a_1062_300# VGND 0.52966f
C518 halfN/dff2/a_475_413# VGND 0.13718f
C519 halfN/dff2/a_634_183# VGND 0.15021f
C520 halfN/dff2/a_193_47# VGND 0.27123f
C521 halfN/dff2/a_27_47# VGND 0.46832f
C522 halfN/xq4/X VGND 1.49783f
C523 halfN/xq4/a_35_297# VGND 0.25457f
C524 RB/R2_3 VGND 9.833f
C525 RB/R1_3 VGND 0.60464f
C526 RB/R2_2 VGND 0.36641f
C527 RB/R1_1 VGND 0.60517f
C528 RARR/R1_3 VGND 1.00474f
C529 RARR/R2_3 VGND 0.39758f
C530 RARR/R2_4 VGND 0.59255f
C531 RT/R1_7 VGND 0.55583f
C532 RT/R2_6 VGND 0.3693f
C533 RT/R1_5 VGND 0.38618f
C534 RT/R2_4 VGND 0.36952f
C535 RT/R1_3 VGND 0.38618f
C536 RT/R2_2 VGND 0.36939f
C537 RT/R1_1 VGND 0.60823f
.ends
